* NGSPICE file created from SAR.ext - technology: sky130A

.subckt OR2 A B Y VP VN
X0 a_100_310# B VP VP sky130_fd_pr__pfet_01v8 ad=0.5 pd=4.25 as=1.466667 ps=9 w=4 l=0.5
**devattr s=56000,1740 d=20000,850
X1 VN B a_n80_n540# VN sky130_fd_pr__nfet_01v8 ad=0.266667 pd=1.866667 as=0.4 ps=2.8 w=1 l=0.5
**devattr s=16000,560 d=8000,280
X2 a_n80_n540# A VN VN sky130_fd_pr__nfet_01v8 ad=0.4 pd=2.8 as=0.266667 ps=1.866667 w=1 l=0.5
**devattr s=8000,280 d=16000,560
X3 a_n80_n540# A a_100_310# VP sky130_fd_pr__pfet_01v8 ad=1.4 pd=8.7 as=0.5 ps=4.25 w=4 l=0.5
**devattr s=20000,850 d=56000,1740
X4 Y a_n80_n540# VN VN sky130_fd_pr__nfet_01v8 ad=0.4 pd=2.8 as=0.266667 ps=1.866667 w=1 l=0.5
**devattr s=16000,560 d=16000,560
X5 Y a_n80_n540# VP VP sky130_fd_pr__pfet_01v8 ad=0.8 pd=4.8 as=0.733333 ps=4.5 w=2 l=0.5
**devattr s=32000,960 d=32000,960
.ends

.subckt x2_1_MUX A B S Y VP VN
X0 Y a_n1230_n310# A VN sky130_fd_pr__nfet_01v8 ad=1.35 pd=6.9 as=1.35 ps=6.9 w=3 l=0.5
**devattr s=54000,1380 d=54000,1380
X1 Y S A VP sky130_fd_pr__pfet_01v8 ad=1.35 pd=6.9 as=1.35 ps=6.9 w=3 l=0.5
**devattr s=54000,1380 d=54000,1380
X2 a_n1230_n310# S VP VP sky130_fd_pr__pfet_01v8 ad=0.9 pd=4.9 as=0.9 ps=4.9 w=2 l=0.5
**devattr s=36000,980 d=36000,980
X3 a_n1230_n310# S VN VN sky130_fd_pr__nfet_01v8 ad=0.45 pd=2.9 as=0.45 ps=2.9 w=1 l=0.5
**devattr s=18000,580 d=18000,580
X4 B a_n1230_n310# Y VP sky130_fd_pr__pfet_01v8 ad=1.35 pd=6.9 as=1.35 ps=6.9 w=3 l=0.5
**devattr s=54000,1380 d=54000,1380
X5 B S a_n530_n280# VN sky130_fd_pr__nfet_01v8 ad=1.35 pd=6.9 as=1.35 ps=6.9 w=3 l=0.5
**devattr s=54000,1380 d=54000,1380
.ends

.subckt DFFR PHIA PHIB D Q RST_N VP VN
X0 a_2090_n400# a_n50_n400# a_450_n400# VP sky130_fd_pr__pfet_01v8 ad=1.38 pd=7.08 as=1.2 ps=6.96 w=3 l=0.5
**devattr s=48000,1360 d=60000,1400
X1 VP a_2090_n400# a_2600_n430# VP sky130_fd_pr__pfet_01v8 ad=0.408333 pd=2.341667 as=0.8 ps=4.8 w=2 l=0.5
**devattr s=32000,960 d=16000,480
X2 VN PHIB a_n420_n400# VN sky130_fd_pr__nfet_01v8 ad=0.295455 pd=1.827273 as=0.4 ps=2.8 w=1 l=0.5
**devattr s=16000,560 d=9000,290
X3 a_2550_n400# a_n50_n400# a_2090_n400# VN sky130_fd_pr__nfet_01v8 ad=0.125 pd=1.25 as=0.475 ps=2.45 w=1 l=0.5
**devattr s=16000,560 d=5000,250
X4 VN a_2600_n430# a_2550_n400# VN sky130_fd_pr__nfet_01v8 ad=0.295455 pd=1.827273 as=0.125 ps=1.25 w=1 l=0.5
**devattr s=5000,250 d=8000,280
X5 a_1460_n400# a_450_n400# a_1310_n400# VN sky130_fd_pr__nfet_01v8 ad=0.375 pd=3.25 as=0.375 ps=3.25 w=3 l=0.5
**devattr s=15000,650 d=15000,650
X6 a_350_n430# a_n420_n400# a_1460_n400# VN sky130_fd_pr__nfet_01v8 ad=1.2 pd=6.8 as=0.375 ps=3.25 w=3 l=0.5
**devattr s=15000,650 d=48000,1360
X7 VN RST_N a_3210_n400# VN sky130_fd_pr__nfet_01v8 ad=0.590909 pd=3.654546 as=0.25 ps=2.25 w=2 l=0.5
**devattr s=10000,450 d=32000,960
X8 a_90_n400# PHIB a_350_n430# VN sky130_fd_pr__nfet_01v8 ad=1.425 pd=7.35 as=1.2 ps=6.8 w=3 l=0.5
**devattr s=48000,1360 d=60000,1400
X9 a_n50_n400# PHIA VP VP sky130_fd_pr__pfet_01v8 ad=0.8 pd=4.8 as=0.408333 ps=2.341667 w=2 l=0.5
**devattr s=18000,490 d=32000,960
X10 a_n50_n400# PHIA VN VN sky130_fd_pr__nfet_01v8 ad=0.4 pd=2.8 as=0.295455 ps=1.827273 w=1 l=0.5
**devattr s=9000,290 d=16000,560
X11 a_2550_720# PHIA a_2090_n400# VP sky130_fd_pr__pfet_01v8 ad=0.25 pd=2.25 as=0.92 ps=4.72 w=2 l=0.5
**devattr s=32000,960 d=10000,450
X12 a_350_n430# PHIB a_1130_520# VP sky130_fd_pr__pfet_01v8 ad=1.608572 pd=8.971429 as=1.066667 ps=5.866667 w=4 l=0.5
**devattr s=32000,880 d=64600,1780
X13 a_1130_520# a_450_n400# VP VP sky130_fd_pr__pfet_01v8 ad=1.066667 pd=5.866667 as=0.816667 ps=4.683333 w=4 l=0.5
**devattr s=32000,880 d=32000,880
X14 Q a_2600_n430# VN VN sky130_fd_pr__nfet_01v8 ad=0.4 pd=2.8 as=0.295455 ps=1.827273 w=1 l=0.5
**devattr s=8000,280 d=16000,560
X15 Q a_2600_n430# VP VP sky130_fd_pr__pfet_01v8 ad=0.8 pd=4.8 as=0.408333 ps=2.341667 w=2 l=0.5
**devattr s=16000,480 d=32000,960
X16 a_90_n400# a_n420_n400# a_350_n430# VP sky130_fd_pr__pfet_01v8 ad=1.38 pd=7.08 as=1.206429 ps=6.728571 w=3 l=0.5
**devattr s=48000,1360 d=60000,1400
X17 a_2600_n430# RST_N VP VP sky130_fd_pr__pfet_01v8 ad=0.8 pd=4.8 as=0.408333 ps=2.341667 w=2 l=0.5
**devattr s=16000,480 d=32000,960
X18 a_450_n400# a_350_n430# VP VP sky130_fd_pr__pfet_01v8 ad=0.8 pd=4.64 as=0.408333 ps=2.341667 w=2 l=0.5
**devattr s=16000,480 d=32000,960
X19 VP RST_N a_1130_520# VP sky130_fd_pr__pfet_01v8 ad=0.816667 pd=4.683333 as=1.066667 ps=5.866667 w=4 l=0.5
**devattr s=64000,1760 d=32000,880
X20 VN D a_90_n400# VN sky130_fd_pr__nfet_01v8 ad=0.295455 pd=1.827273 as=0.475 ps=2.45 w=1 l=0.5
**devattr s=16000,560 d=8000,280
X21 a_2090_n400# PHIA a_450_n400# VN sky130_fd_pr__nfet_01v8 ad=1.425 pd=7.35 as=1.2 ps=7.2 w=3 l=0.5
**devattr s=48000,1360 d=60000,1400
X22 VP D a_90_n400# VP sky130_fd_pr__pfet_01v8 ad=0.408333 pd=2.341667 as=0.92 ps=4.72 w=2 l=0.5
**devattr s=32000,960 d=16000,480
X23 a_450_n400# a_350_n430# VN VN sky130_fd_pr__nfet_01v8 ad=0.4 pd=2.4 as=0.295455 ps=1.827273 w=1 l=0.5
**devattr s=8000,280 d=16000,560
X24 a_1310_n400# RST_N VN VN sky130_fd_pr__nfet_01v8 ad=0.375 pd=3.25 as=0.886364 ps=5.481818 w=3 l=0.5
**devattr s=48000,1360 d=15000,650
X25 VP PHIB a_n420_n400# VP sky130_fd_pr__pfet_01v8 ad=0.408333 pd=2.341667 as=0.8 ps=4.8 w=2 l=0.5
**devattr s=32000,960 d=18000,490
X26 a_3210_n400# a_2090_n400# a_2600_n430# VN sky130_fd_pr__nfet_01v8 ad=0.25 pd=2.25 as=0.8 ps=4.8 w=2 l=0.5
**devattr s=32000,960 d=10000,450
X27 VP a_2600_n430# a_2550_720# VP sky130_fd_pr__pfet_01v8 ad=0.408333 pd=2.341667 as=0.25 ps=2.25 w=2 l=0.5
**devattr s=10000,450 d=16000,480
.ends

.subckt DFFRR PHIA PHIB D Q RST_N RST VP VN
X0 a_n420_720# D VP VP sky130_fd_pr__pfet_01v8 ad=0.885714 pd=4.742857 as=0.407143 ps=2.35 w=2 l=0.5
**devattr s=16000,480 d=32000,960
X1 a_2090_n400# a_n560_n400# a_450_n400# VP sky130_fd_pr__pfet_01v8 ad=1.38 pd=7.08 as=1.2 ps=6.96 w=3 l=0.5
**devattr s=48000,1360 d=60000,1400
X2 a_n420_720# D a_n240_n400# VN sky130_fd_pr__nfet_01v8 ad=0.92 pd=4.72 as=0.25 ps=2.25 w=2 l=0.5
**devattr s=10000,450 d=32000,960
X3 VP a_2090_n400# a_2600_n430# VP sky130_fd_pr__pfet_01v8 ad=0.407143 pd=2.35 as=0.8 ps=4.8 w=2 l=0.5
**devattr s=32000,960 d=16000,480
X4 a_n240_n400# a_n340_n430# VN VN sky130_fd_pr__nfet_01v8 ad=0.25 pd=2.25 as=0.623077 ps=3.830769 w=2 l=0.5
**devattr s=32000,960 d=10000,450
X5 a_2550_n400# a_n560_n400# a_2090_n400# VN sky130_fd_pr__nfet_01v8 ad=0.125 pd=1.25 as=0.475 ps=2.45 w=1 l=0.5
**devattr s=16000,560 d=5000,250
X6 VN a_2600_n430# a_2550_n400# VN sky130_fd_pr__nfet_01v8 ad=0.311538 pd=1.915385 as=0.125 ps=1.25 w=1 l=0.5
**devattr s=5000,250 d=8000,280
X7 a_1460_n400# a_450_n400# a_1310_n400# VN sky130_fd_pr__nfet_01v8 ad=0.375 pd=3.25 as=0.375 ps=3.25 w=3 l=0.5
**devattr s=15000,650 d=15000,650
X8 a_350_n430# a_n930_n400# a_1460_n400# VN sky130_fd_pr__nfet_01v8 ad=1.2 pd=6.8 as=0.375 ps=3.25 w=3 l=0.5
**devattr s=15000,650 d=48000,1360
X9 VP PHIB a_n930_n400# VP sky130_fd_pr__pfet_01v8 ad=0.407143 pd=2.35 as=0.8 ps=4.8 w=2 l=0.5
**devattr s=32000,960 d=18000,490
X10 VN RST_N a_3210_n400# VN sky130_fd_pr__nfet_01v8 ad=0.623077 pd=3.830769 as=0.25 ps=2.25 w=2 l=0.5
**devattr s=10000,450 d=32000,960
X11 a_n420_720# PHIB a_350_n430# VN sky130_fd_pr__nfet_01v8 ad=1.38 pd=7.08 as=1.2 ps=6.8 w=3 l=0.5
**devattr s=48000,1360 d=60000,1400
X12 a_2550_720# PHIA a_2090_n400# VP sky130_fd_pr__pfet_01v8 ad=0.25 pd=2.25 as=0.92 ps=4.72 w=2 l=0.5
**devattr s=32000,960 d=10000,450
X13 a_350_n430# PHIB a_1130_520# VP sky130_fd_pr__pfet_01v8 ad=1.608572 pd=8.971429 as=1.066667 ps=5.866667 w=4 l=0.5
**devattr s=32000,880 d=64600,1780
X14 a_1130_520# a_450_n400# VP VP sky130_fd_pr__pfet_01v8 ad=1.066667 pd=5.866667 as=0.814286 ps=4.7 w=4 l=0.5
**devattr s=32000,880 d=32000,880
X15 Q a_2600_n430# VN VN sky130_fd_pr__nfet_01v8 ad=0.4 pd=2.8 as=0.311538 ps=1.915385 w=1 l=0.5
**devattr s=8000,280 d=16000,560
X16 a_n560_n400# PHIA VP VP sky130_fd_pr__pfet_01v8 ad=0.8 pd=4.8 as=0.407143 ps=2.35 w=2 l=0.5
**devattr s=18000,490 d=32000,960
X17 VN PHIB a_n930_n400# VN sky130_fd_pr__nfet_01v8 ad=0.311538 pd=1.915385 as=0.4 ps=2.8 w=1 l=0.5
**devattr s=16000,560 d=9000,290
X18 Q a_2600_n430# VP VP sky130_fd_pr__pfet_01v8 ad=0.8 pd=4.8 as=0.407143 ps=2.35 w=2 l=0.5
**devattr s=16000,480 d=32000,960
X19 a_n420_720# a_n930_n400# a_350_n430# VP sky130_fd_pr__pfet_01v8 ad=1.328571 pd=7.114286 as=1.206429 ps=6.728571 w=3 l=0.5
**devattr s=48000,1360 d=60000,1400
X20 a_2600_n430# RST_N VP VP sky130_fd_pr__pfet_01v8 ad=0.8 pd=4.8 as=0.407143 ps=2.35 w=2 l=0.5
**devattr s=16000,480 d=32000,960
X21 a_450_n400# a_350_n430# VP VP sky130_fd_pr__pfet_01v8 ad=0.8 pd=4.64 as=0.407143 ps=2.35 w=2 l=0.5
**devattr s=16000,480 d=32000,960
X22 a_n560_n400# PHIA VN VN sky130_fd_pr__nfet_01v8 ad=0.4 pd=2.8 as=0.311538 ps=1.915385 w=1 l=0.5
**devattr s=9000,290 d=16000,560
X23 VP RST_N a_1130_520# VP sky130_fd_pr__pfet_01v8 ad=0.814286 pd=4.7 as=1.066667 ps=5.866667 w=4 l=0.5
**devattr s=64000,1760 d=32000,880
X24 VN RST a_n340_n430# VN sky130_fd_pr__nfet_01v8 ad=0.311538 pd=1.915385 as=0.4 ps=2.8 w=1 l=0.5
**devattr s=16000,560 d=8000,280
X25 a_2090_n400# PHIA a_450_n400# VN sky130_fd_pr__nfet_01v8 ad=1.425 pd=7.35 as=1.2 ps=7.2 w=3 l=0.5
**devattr s=48000,1360 d=60000,1400
X26 VP RST a_n340_n430# VP sky130_fd_pr__pfet_01v8 ad=0.407143 pd=2.35 as=0.8 ps=4.8 w=2 l=0.5
**devattr s=32000,960 d=16000,480
X27 a_450_n400# a_350_n430# VN VN sky130_fd_pr__nfet_01v8 ad=0.4 pd=2.4 as=0.311538 ps=1.915385 w=1 l=0.5
**devattr s=8000,280 d=16000,560
X28 a_1310_n400# RST_N VN VN sky130_fd_pr__nfet_01v8 ad=0.375 pd=3.25 as=0.934615 ps=5.746154 w=3 l=0.5
**devattr s=48000,1360 d=15000,650
X29 VP a_n340_n430# a_n420_720# VP sky130_fd_pr__pfet_01v8 ad=0.407143 pd=2.35 as=0.885714 ps=4.742857 w=2 l=0.5
**devattr s=32000,960 d=16000,480
X30 a_3210_n400# a_2090_n400# a_2600_n430# VN sky130_fd_pr__nfet_01v8 ad=0.25 pd=2.25 as=0.8 ps=4.8 w=2 l=0.5
**devattr s=32000,960 d=10000,450
X31 VP a_2600_n430# a_2550_720# VP sky130_fd_pr__pfet_01v8 ad=0.407143 pd=2.35 as=0.25 ps=2.25 w=2 l=0.5
**devattr s=10000,450 d=16000,480
.ends

.subckt AND2 A B Y VP VN
X0 a_90_n200# B VN VN sky130_fd_pr__nfet_01v8 ad=0.25 pd=2.25 as=0.8 ps=5.066667 w=2 l=0.5
**devattr s=32000,960 d=10000,450
X1 a_n100_1100# A a_90_n200# VN sky130_fd_pr__nfet_01v8 ad=0.8 pd=4.8 as=0.25 ps=2.25 w=2 l=0.5
**devattr s=10000,450 d=32000,960
X2 Y a_n100_1100# VN VN sky130_fd_pr__nfet_01v8 ad=0.4 pd=2.8 as=0.4 ps=2.533333 w=1 l=0.5
**devattr s=16000,560 d=16000,560
X3 VP B a_n100_1100# VP sky130_fd_pr__pfet_01v8 ad=0.567055 pd=3.234609 as=0.9 ps=4.9 w=2 l=0.5
**devattr s=36000,980 d=18000,490
X4 a_n100_1100# A VP VP sky130_fd_pr__pfet_01v8 ad=0.9 pd=4.9 as=0.567055 ps=3.234609 w=2 l=0.5
**devattr s=18000,490 d=36000,980
X5 Y a_n100_1100# VP VP sky130_fd_pr__pfet_01v8 ad=0.804 pd=4.82 as=0.56989 ps=3.250782 w=2.01 l=0.5
**devattr s=32160,964 d=32160,964
.ends

.subckt DFFS PHIA PHIB D Q SET_N VP VN
X0 a_2090_n400# a_n50_n400# a_350_n430# VP sky130_fd_pr__pfet_01v8 ad=1.328571 pd=7.114286 as=1.2 ps=6.685714 w=3 l=0.5
**devattr s=48000,1360 d=60000,1400
X1 VP a_600_n400# a_2090_n400# VP sky130_fd_pr__pfet_01v8 ad=0.408333 pd=2.341667 as=0.885714 ps=4.742857 w=2 l=0.5
**devattr s=32000,960 d=16000,480
X2 VN PHIB a_n420_n400# VN sky130_fd_pr__nfet_01v8 ad=0.295455 pd=1.827273 as=0.4 ps=2.8 w=1 l=0.5
**devattr s=16000,560 d=9000,290
X3 a_2550_n400# a_n420_n400# a_600_n400# VN sky130_fd_pr__nfet_01v8 ad=0.125 pd=1.25 as=0.4 ps=2.4 w=1 l=0.5
**devattr s=16000,560 d=5000,250
X4 VN a_2090_n400# a_2550_n400# VN sky130_fd_pr__nfet_01v8 ad=0.295455 pd=1.827273 as=0.125 ps=1.25 w=1 l=0.5
**devattr s=5000,250 d=8000,280
X5 a_1460_n400# a_450_n400# a_1310_n400# VN sky130_fd_pr__nfet_01v8 ad=0.375 pd=3.25 as=0.375 ps=3.25 w=3 l=0.5
**devattr s=15000,650 d=15000,650
X6 a_350_n430# a_n50_n400# a_1460_n400# VN sky130_fd_pr__nfet_01v8 ad=1.2 pd=6.8 as=0.375 ps=3.25 w=3 l=0.5
**devattr s=15000,650 d=48000,1360
X7 VN SET_N a_3210_n400# VN sky130_fd_pr__nfet_01v8 ad=0.590909 pd=3.654546 as=0.25 ps=2.25 w=2 l=0.5
**devattr s=10000,450 d=32000,960
X8 a_90_n400# PHIB a_600_n400# VN sky130_fd_pr__nfet_01v8 ad=1.425 pd=7.35 as=1.2 ps=7.2 w=3 l=0.5
**devattr s=48000,1360 d=60000,1400
X9 a_n50_n400# PHIA VP VP sky130_fd_pr__pfet_01v8 ad=0.8 pd=4.8 as=0.408333 ps=2.341667 w=2 l=0.5
**devattr s=18000,490 d=32000,960
X10 a_n50_n400# PHIA VN VN sky130_fd_pr__nfet_01v8 ad=0.4 pd=2.8 as=0.295455 ps=1.827273 w=1 l=0.5
**devattr s=9000,290 d=16000,560
X11 a_2550_720# PHIB a_600_n400# VP sky130_fd_pr__pfet_01v8 ad=0.25 pd=2.25 as=0.8 ps=4.64 w=2 l=0.5
**devattr s=32000,960 d=10000,450
X12 a_350_n430# PHIA a_1130_520# VP sky130_fd_pr__pfet_01v8 ad=1.6 pd=8.914286 as=1.066667 ps=5.866667 w=4 l=0.5
**devattr s=32000,880 d=64000,1760
X13 a_1130_520# a_450_n400# VP VP sky130_fd_pr__pfet_01v8 ad=1.066667 pd=5.866667 as=0.816667 ps=4.683333 w=4 l=0.5
**devattr s=32000,880 d=32000,880
X14 Q a_450_n400# VN VN sky130_fd_pr__nfet_01v8 ad=0.4 pd=2.8 as=0.295455 ps=1.827273 w=1 l=0.5
**devattr s=8000,280 d=16000,560
X15 Q a_450_n400# VP VP sky130_fd_pr__pfet_01v8 ad=0.8 pd=4.8 as=0.408333 ps=2.341667 w=2 l=0.5
**devattr s=16000,480 d=32000,960
X16 a_90_n400# a_n420_n400# a_600_n400# VP sky130_fd_pr__pfet_01v8 ad=1.38 pd=7.08 as=1.2 ps=6.96 w=3 l=0.5
**devattr s=48000,1360 d=60000,1400
X17 a_2090_n400# SET_N VP VP sky130_fd_pr__pfet_01v8 ad=0.885714 pd=4.742857 as=0.408333 ps=2.341667 w=2 l=0.5
**devattr s=16000,480 d=32000,960
X18 a_450_n400# a_350_n430# VP VP sky130_fd_pr__pfet_01v8 ad=0.8 pd=4.8 as=0.408333 ps=2.341667 w=2 l=0.5
**devattr s=16000,480 d=32000,960
X19 VP SET_N a_1130_520# VP sky130_fd_pr__pfet_01v8 ad=0.816667 pd=4.683333 as=1.066667 ps=5.866667 w=4 l=0.5
**devattr s=64000,1760 d=32000,880
X20 VN D a_90_n400# VN sky130_fd_pr__nfet_01v8 ad=0.295455 pd=1.827273 as=0.475 ps=2.45 w=1 l=0.5
**devattr s=16000,560 d=8000,280
X21 a_2090_n400# PHIA a_350_n430# VN sky130_fd_pr__nfet_01v8 ad=1.38 pd=7.08 as=1.2 ps=6.8 w=3 l=0.5
**devattr s=48000,1360 d=60000,1400
X22 VP D a_90_n400# VP sky130_fd_pr__pfet_01v8 ad=0.408333 pd=2.341667 as=0.92 ps=4.72 w=2 l=0.5
**devattr s=32000,960 d=16000,480
X23 a_450_n400# a_350_n430# VN VN sky130_fd_pr__nfet_01v8 ad=0.4 pd=2.8 as=0.295455 ps=1.827273 w=1 l=0.5
**devattr s=8000,280 d=16000,560
X24 a_1310_n400# SET_N VN VN sky130_fd_pr__nfet_01v8 ad=0.375 pd=3.25 as=0.886364 ps=5.481818 w=3 l=0.5
**devattr s=48000,1360 d=15000,650
X25 VP PHIB a_n420_n400# VP sky130_fd_pr__pfet_01v8 ad=0.408333 pd=2.341667 as=0.8 ps=4.8 w=2 l=0.5
**devattr s=32000,960 d=18000,490
X26 a_3210_n400# a_600_n400# a_2090_n400# VN sky130_fd_pr__nfet_01v8 ad=0.25 pd=2.25 as=0.92 ps=4.72 w=2 l=0.5
**devattr s=32000,960 d=10000,450
X27 VP a_2090_n400# a_2550_720# VP sky130_fd_pr__pfet_01v8 ad=0.408333 pd=2.341667 as=0.25 ps=2.25 w=2 l=0.5
**devattr s=10000,450 d=16000,480
.ends

.subckt SAR COMP RST_N PHIA PHIB ADC_OUT_B3 ADC_OUT_B2 ADC_OUT_B1 ADC_OUT_B0 DAC_B3
+ DAC_B2 DAC_B1 DAC_B0 VP VN
XOR2_0 OR2_0/A OR2_0/B DAC_B1 VP VN OR2
XOR2_1 OR2_1/A OR2_1/B DAC_B2 VP VN OR2
X2_1_MUX_0 OR2_0/A COMP OR2_0/B DFFRR_1/D VP VN x2_1_MUX
XOR2_2 OR2_2/A OR2_2/B DAC_B3 VP VN OR2
X2_1_MUX_1 OR2_1/A COMP OR2_1/B DFFRR_0/D VP VN x2_1_MUX
X2_1_MUX_2 OR2_2/A COMP OR2_2/B DFFR_7/D VP VN x2_1_MUX
XDFFR_0 PHIA PHIB OR2_2/B OR2_1/B RST_N VP VN DFFR
XDFFRR_0 PHIA PHIB DFFRR_0/D OR2_1/A RST_N DAC_B0 VP VN DFFRR
XDFFR_1 PHIA PHIB OR2_1/B OR2_0/B RST_N VP VN DFFR
XDFFRR_1 PHIA PHIB DFFRR_1/D OR2_0/A RST_N DAC_B0 VP VN DFFRR
XDFFR_3 AND2_0/Y AND2_1/Y DFFR_3/D ADC_OUT_B0 RST_N VP VN DFFR
XDFFR_2 PHIA PHIB OR2_0/B DAC_B0 RST_N VP VN DFFR
XDFFR_4 AND2_0/Y AND2_1/Y OR2_0/A ADC_OUT_B1 RST_N VP VN DFFR
XDFFR_5 AND2_0/Y AND2_1/Y OR2_1/A ADC_OUT_B2 RST_N VP VN DFFR
XDFFR_6 AND2_0/Y AND2_1/Y OR2_2/A ADC_OUT_B3 RST_N VP VN DFFR
XDFFR_7 PHIA PHIB DFFR_7/D OR2_2/A RST_N VP VN DFFR
XAND2_0 PHIA DAC_B0 AND2_0/Y VP VN AND2
XAND2_1 PHIB DAC_B0 AND2_1/Y VP VN AND2
XAND2_2 DAC_B0 COMP DFFR_3/D VP VN AND2
XDFFS_0 PHIA PHIB DAC_B0 OR2_2/B RST_N VP VN DFFS
.ends
