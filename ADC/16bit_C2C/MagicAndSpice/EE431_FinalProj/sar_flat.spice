* NGSPICE file created from sar_flat.ext - technology: sky130A

.subckt SAR_LAYOUT COMP RST_N PHIA PHIB ADC_OUT_B3 ADC_OUT_B2 ADC_OUT_B1 ADC_OUT_B0
+ DAC_B3 DAC_B2 DAC_B1 DAC_B0 VP VN
X0 a_8030_5580# 2_1_MUX_0.Y VP VP sky130_fd_pr__pfet_01v8 ad=0.8 pd=4.8 as=0.4 ps=2.4 w=2 l=0.5
X1 a_9910_4460# a_8900_4460# a_9760_4460# VN sky130_fd_pr__nfet_01v8 ad=0.375 pd=3.25 as=0.375 ps=3.25 w=3 l=0.5
X2 VP PHIB a_4050_200# VP sky130_fd_pr__pfet_01v8 ad=0.45 pd=2.45 as=0.8 ps=4.8 w=2 l=0.5
X3 a_11660_8720# a_10540_8720# a_11050_8690# VN sky130_fd_pr__nfet_01v8 ad=0.25 pd=2.25 as=0.8 ps=4.8 w=2 l=0.5
X4 VN RST_N a_11660_8720# VN sky130_fd_pr__nfet_01v8 ad=0.8 pd=4.8 as=0.25 ps=2.25 w=2 l=0.5
X5 a_12880_6800# a_12780_6770# VP VP sky130_fd_pr__pfet_01v8 ad=0.8 pd=4.8 as=0.4 ps=2.4 w=2 l=0.5
X6 a_7890_4460# PHIA VN VN sky130_fd_pr__nfet_01v8 ad=0.4 pd=2.8 as=0.225 ps=1.45 w=1 l=0.5
X7 a_14520_4460# AND2_0.Y a_12880_4460# VN sky130_fd_pr__nfet_01v8 ad=1.5 pd=7 as=1.2 ps=6.8 w=3 l=0.5
X8 a_12380_200# PHIA VN VN sky130_fd_pr__nfet_01v8 ad=0.4 pd=2.8 as=0.225 ps=1.45 w=1 l=0.5
X9 a_14520_8720# a_12380_8720# a_12880_8720# VP sky130_fd_pr__pfet_01v8 ad=1.5 pd=7 as=1.2 ps=6.8 w=3 l=0.5
X10 a_7890_6800# PHIA VN VN sky130_fd_pr__nfet_01v8 ad=0.4 pd=2.8 as=0.225 ps=1.45 w=1 l=0.5
X11 a_13740_4460# RST_N VN VN sky130_fd_pr__nfet_01v8 ad=0.375 pd=3.25 as=1.2 ps=6.8 w=3 l=0.5
X12 a_13890_200# a_12880_200# a_13740_200# VN sky130_fd_pr__nfet_01v8 ad=0.375 pd=3.25 as=0.375 ps=3.25 w=3 l=0.5
X13 DFFR_0.Q a_7070_170# VN VN sky130_fd_pr__nfet_01v8 ad=0.4 pd=2.8 as=0.2 ps=1.4 w=1 l=0.5
X14 a_8030_5580# 2_1_MUX_0.Y a_8210_4460# VN sky130_fd_pr__nfet_01v8 ad=0.8 pd=4.8 as=0.25 ps=2.25 w=2 l=0.5
X15 VP RST_N a_9580_1120# VP sky130_fd_pr__pfet_01v8 ad=0.8 pd=4.4 as=1.6 ps=8.8 w=4 l=0.5
X16 a_8400_200# PHIA VP VP sky130_fd_pr__pfet_01v8 ad=0.8 pd=4.8 as=0.45 ps=2.45 w=2 l=0.5
X17 a_11050_8690# RST_N VP VP sky130_fd_pr__pfet_01v8 ad=0.8 pd=4.8 as=0.4 ps=2.4 w=2 l=0.5
X18 a_12380_8720# AND2_0.Y VN VN sky130_fd_pr__nfet_01v8 ad=0.4 pd=2.8 as=0.225 ps=1.45 w=1 l=0.5
X19 a_9580_6600# a_8900_6800# VP VP sky130_fd_pr__pfet_01v8 ad=0.8 pd=4.4 as=0.8 ps=4.4 w=4 l=0.5
X20 ADC_OUT_B2 a_15030_6770# VP VP sky130_fd_pr__pfet_01v8 ad=0.8 pd=4.8 as=0.4 ps=2.4 w=2 l=0.5
X21 a_12780_4430# AND2_1.Y a_13560_5380# VP sky130_fd_pr__pfet_01v8 ad=1.615 pd=8.9 as=0.8 ps=4.4 w=4 l=0.5
X22 a_14520_2340# AND2_0.Y a_12880_2540# VN sky130_fd_pr__nfet_01v8 ad=1.5 pd=7 as=1.2 ps=6.8 w=3 l=0.5
X23 a_14980_3860# a_12380_2540# a_14520_2340# VN sky130_fd_pr__nfet_01v8 ad=0.125 pd=1.25 as=0.4 ps=2.8 w=1 l=0.5
X24 VP a_15030_170# a_14980_1320# VP sky130_fd_pr__pfet_01v8 ad=0.4 pd=2.4 as=0.25 ps=2.25 w=2 l=0.5
X25 VN RST_N a_7680_200# VN sky130_fd_pr__nfet_01v8 ad=0.8 pd=4.8 as=0.25 ps=2.25 w=2 l=0.5
X26 a_13740_3460# RST_N VN VN sky130_fd_pr__nfet_01v8 ad=0.375 pd=3.25 as=1.2 ps=6.8 w=3 l=0.5
X27 DAC_B2 a_7210_3870# VN VN sky130_fd_pr__nfet_01v8 ad=0.4 pd=2.8 as=0.4 ps=2.8 w=1 l=0.5
X28 COMP a_6970_9610# 2_1_MUX_2.Y VN sky130_fd_pr__nfet_01v8 ad=1.35 pd=6.9 as=1.35 ps=6.9 w=3 l=0.5
X29 VN AND2_1.Y a_12010_4460# VN sky130_fd_pr__nfet_01v8 ad=0.225 pd=1.45 as=0.4 ps=2.8 w=1 l=0.5
X30 a_12380_2540# AND2_0.Y VP VP sky130_fd_pr__pfet_01v8 ad=0.8 pd=4.8 as=0.45 ps=2.45 w=2 l=0.5
X31 VP AND2_1.Y a_12010_8720# VP sky130_fd_pr__pfet_01v8 ad=0.45 pd=2.45 as=0.8 ps=4.8 w=2 l=0.5
X32 a_15640_4460# a_14520_4460# a_15030_4430# VN sky130_fd_pr__nfet_01v8 ad=0.25 pd=2.25 as=0.8 ps=4.8 w=2 l=0.5
X33 DAC_B0 a_15030_170# VN VN sky130_fd_pr__nfet_01v8 ad=0.4 pd=2.8 as=0.2 ps=1.4 w=1 l=0.5
X34 a_3700_200# a_1090_200# a_2580_200# VN sky130_fd_pr__nfet_01v8 ad=0.25 pd=2.25 as=0.8 ps=4.8 w=2 l=0.5
X35 VN AND2_1.Y a_12010_6800# VN sky130_fd_pr__nfet_01v8 ad=0.225 pd=1.45 as=0.4 ps=2.8 w=1 l=0.5
X36 a_8030_5580# PHIB a_8800_4430# VN sky130_fd_pr__nfet_01v8 ad=1.5 pd=7 as=1.2 ps=6.8 w=3 l=0.5
X37 VP RST_N a_13560_1120# VP sky130_fd_pr__pfet_01v8 ad=0.8 pd=4.4 as=1.6 ps=8.8 w=4 l=0.5
X38 a_9760_200# RST_N VN VN sky130_fd_pr__nfet_01v8 ad=0.375 pd=3.25 as=1.2 ps=6.8 w=3 l=0.5
X39 a_13560_6600# a_12880_6800# VP VP sky130_fd_pr__pfet_01v8 ad=0.8 pd=4.4 as=0.8 ps=4.4 w=4 l=0.5
X40 a_14980_5580# AND2_0.Y a_14520_4460# VP sky130_fd_pr__pfet_01v8 ad=0.25 pd=2.25 as=0.8 ps=4.8 w=2 l=0.5
X41 a_11050_2360# PHIA a_11240_3660# VN sky130_fd_pr__nfet_01v8 ad=0.8 pd=4.8 as=0.25 ps=2.25 w=2 l=0.5
X42 a_11000_6800# PHIA a_10540_6600# VP sky130_fd_pr__pfet_01v8 ad=0.25 pd=2.25 as=0.8 ps=4.8 w=2 l=0.5
X43 VP DAC_B0 a_8110_4430# VP sky130_fd_pr__pfet_01v8 ad=0.4 pd=2.4 as=0.8 ps=4.8 w=2 l=0.5
X44 VN AND2_2.Y a_12520_2540# VN sky130_fd_pr__nfet_01v8 ad=0.2 pd=1.4 as=0.4 ps=2.8 w=1 l=0.5
X45 VN PHIB a_8030_200# VN sky130_fd_pr__nfet_01v8 ad=0.225 pd=1.45 as=0.4 ps=2.8 w=1 l=0.5
X46 VP a_8110_6770# a_8030_6800# VP sky130_fd_pr__pfet_01v8 ad=0.4 pd=2.4 as=0.8 ps=4.8 w=2 l=0.5
X47 a_12880_200# a_12780_170# VP VP sky130_fd_pr__pfet_01v8 ad=0.8 pd=4.8 as=0.4 ps=2.4 w=2 l=0.5
X48 VN a_7070_170# a_7020_200# VN sky130_fd_pr__nfet_01v8 ad=0.2 pd=1.4 as=0.125 ps=1.25 w=1 l=0.5
X49 a_840_170# a_440_200# a_1950_200# VN sky130_fd_pr__nfet_01v8 ad=1.2 pd=6.8 as=0.375 ps=3.25 w=3 l=0.5
X50 VP PHIB a_70_200# VP sky130_fd_pr__pfet_01v8 ad=0.45 pd=2.45 as=0.8 ps=4.8 w=2 l=0.5
X51 a_9760_8720# RST_N VN VN sky130_fd_pr__nfet_01v8 ad=0.375 pd=3.25 as=1.2 ps=6.8 w=3 l=0.5
X52 a_12520_4460# AND2_1.Y a_12780_4430# VN sky130_fd_pr__nfet_01v8 ad=1.5 pd=7 as=1.2 ps=6.8 w=3 l=0.5
X53 a_840_170# PHIA a_1620_1120# VP sky130_fd_pr__pfet_01v8 ad=1.6 pd=8.8 as=0.8 ps=4.4 w=4 l=0.5
X54 a_9910_8720# a_8900_8720# a_9760_8720# VN sky130_fd_pr__nfet_01v8 ad=0.375 pd=3.25 as=0.375 ps=3.25 w=3 l=0.5
X55 a_9130_2360# DAC_B0 VP VP sky130_fd_pr__pfet_01v8 ad=0.9 pd=4.9 as=0.45 ps=2.45 w=2 l=0.5
X56 2_1_MUX_2.Y a_6970_9610# OR2_2.A VP sky130_fd_pr__pfet_01v8 ad=1.35 pd=6.9 as=1.35 ps=6.9 w=3 l=0.5
X57 a_6970_9610# DFFR_0.D VP VP sky130_fd_pr__pfet_01v8 ad=0.9 pd=4.9 as=0.9 ps=4.9 w=2 l=0.5
X58 VP OR2_0.A a_12520_4460# VP sky130_fd_pr__pfet_01v8 ad=0.4 pd=2.4 as=0.8 ps=4.8 w=2 l=0.5
X59 DAC_B3 a_6210_3870# VN VN sky130_fd_pr__nfet_01v8 ad=0.4 pd=2.8 as=0.4 ps=2.8 w=1 l=0.5
X60 DAC_B0 a_15030_170# VP VP sky130_fd_pr__pfet_01v8 ad=0.8 pd=4.8 as=0.4 ps=2.4 w=2 l=0.5
X61 a_9580_1120# a_8900_200# VP VP sky130_fd_pr__pfet_01v8 ad=0.8 pd=4.4 as=0.8 ps=4.4 w=4 l=0.5
X62 a_8540_200# a_8030_200# a_8800_170# VP sky130_fd_pr__pfet_01v8 ad=1.5 pd=7 as=1.2 ps=6.8 w=3 l=0.5
X63 a_6460_5350# DFFR_1.Q VP VP sky130_fd_pr__pfet_01v8 ad=0.9 pd=4.9 as=0.9 ps=4.9 w=2 l=0.5
X64 VN a_15030_170# a_14980_200# VN sky130_fd_pr__nfet_01v8 ad=0.2 pd=1.4 as=0.125 ps=1.25 w=1 l=0.5
X65 a_7020_1320# PHIA a_6560_200# VP sky130_fd_pr__pfet_01v8 ad=0.25 pd=2.25 as=0.8 ps=4.8 w=2 l=0.5
X66 VP a_14520_8720# a_15030_8690# VP sky130_fd_pr__pfet_01v8 ad=0.4 pd=2.4 as=0.8 ps=4.8 w=2 l=0.5
X67 a_14520_8720# AND2_0.Y a_12880_8720# VN sky130_fd_pr__nfet_01v8 ad=1.5 pd=7 as=1.2 ps=6.8 w=3 l=0.5
X68 a_9760_7720# RST_N VN VN sky130_fd_pr__nfet_01v8 ad=0.375 pd=3.25 as=1.2 ps=6.8 w=3 l=0.5
X69 a_12520_2540# AND2_1.Y a_12780_2510# VN sky130_fd_pr__nfet_01v8 ad=1.5 pd=7 as=1.2 ps=6.8 w=3 l=0.5
X70 a_13740_8720# RST_N VN VN sky130_fd_pr__nfet_01v8 ad=0.375 pd=3.25 as=1.2 ps=6.8 w=3 l=0.5
X71 a_9910_7720# a_8900_6800# a_9760_7720# VN sky130_fd_pr__nfet_01v8 ad=0.375 pd=3.25 as=0.375 ps=3.25 w=3 l=0.5
X72 a_6560_200# a_4420_200# a_4920_200# VP sky130_fd_pr__pfet_01v8 ad=1.5 pd=7 as=1.2 ps=6.8 w=3 l=0.5
X73 AND2_2.Y a_9130_2360# VN VN sky130_fd_pr__nfet_01v8 ad=0.4 pd=2.8 as=0.4 ps=2.8 w=1 l=0.5
X74 VP a_14520_2340# a_15030_2510# VP sky130_fd_pr__pfet_01v8 ad=0.4 pd=2.4 as=0.8 ps=4.8 w=2 l=0.5
X75 a_8800_170# a_8030_200# a_9910_200# VN sky130_fd_pr__nfet_01v8 ad=1.2 pd=6.8 as=0.375 ps=3.25 w=3 l=0.5
X76 COMP DFFR_1.Q 2_1_MUX_0.Y VP sky130_fd_pr__pfet_01v8 ad=1.35 pd=6.9 as=1.35 ps=6.9 w=3 l=0.5
X77 a_13560_1120# a_12880_200# VP VP sky130_fd_pr__pfet_01v8 ad=0.8 pd=4.4 as=0.8 ps=4.4 w=4 l=0.5
X78 a_12520_200# a_12010_200# a_12780_170# VP sky130_fd_pr__pfet_01v8 ad=1.5 pd=7 as=1.2 ps=6.8 w=3 l=0.5
X79 a_12780_8690# AND2_1.Y a_13560_9640# VP sky130_fd_pr__pfet_01v8 ad=1.615 pd=8.9 as=0.8 ps=4.4 w=4 l=0.5
X80 a_14520_6600# AND2_0.Y a_12880_6800# VN sky130_fd_pr__nfet_01v8 ad=1.5 pd=7 as=1.2 ps=6.8 w=3 l=0.5
X81 VP a_11050_4430# a_11000_5580# VP sky130_fd_pr__pfet_01v8 ad=0.4 pd=2.4 as=0.25 ps=2.25 w=2 l=0.5
X82 a_2580_200# RST_N VP VP sky130_fd_pr__pfet_01v8 ad=0.8 pd=4.8 as=0.4 ps=2.4 w=2 l=0.5
X83 a_11000_1320# PHIA a_10540_200# VP sky130_fd_pr__pfet_01v8 ad=0.25 pd=2.25 as=0.8 ps=4.8 w=2 l=0.5
X84 a_13740_7720# RST_N VN VN sky130_fd_pr__nfet_01v8 ad=0.375 pd=3.25 as=1.2 ps=6.8 w=3 l=0.5
X85 a_12380_6800# AND2_0.Y VP VP sky130_fd_pr__pfet_01v8 ad=0.8 pd=4.8 as=0.45 ps=2.45 w=2 l=0.5
X86 a_8900_4460# a_8800_4430# VP VP sky130_fd_pr__pfet_01v8 ad=0.8 pd=4.8 as=0.4 ps=2.4 w=2 l=0.5
X87 a_10540_200# a_8400_200# a_8900_200# VP sky130_fd_pr__pfet_01v8 ad=1.5 pd=7 as=1.2 ps=6.8 w=3 l=0.5
X88 VP PHIB a_8030_200# VP sky130_fd_pr__pfet_01v8 ad=0.45 pd=2.45 as=0.8 ps=4.8 w=2 l=0.5
X89 a_5930_200# a_4920_200# a_5780_200# VN sky130_fd_pr__nfet_01v8 ad=0.375 pd=3.25 as=0.375 ps=3.25 w=3 l=0.5
X90 a_4420_200# PHIA VN VN sky130_fd_pr__nfet_01v8 ad=0.4 pd=2.8 as=0.225 ps=1.45 w=1 l=0.5
X91 VN AND2_1.Y a_12010_8720# VN sky130_fd_pr__nfet_01v8 ad=0.225 pd=1.45 as=0.4 ps=2.8 w=1 l=0.5
X92 a_15640_8720# a_14520_8720# a_15030_8690# VN sky130_fd_pr__nfet_01v8 ad=0.25 pd=2.25 as=0.8 ps=4.8 w=2 l=0.5
X93 a_8800_4430# a_7520_4460# a_9910_4460# VN sky130_fd_pr__nfet_01v8 ad=1.2 pd=6.8 as=0.375 ps=3.25 w=3 l=0.5
X94 a_8390_2420# DFFR_1.Q VP VP sky130_fd_pr__pfet_01v8 ad=0.5 pd=4.25 as=1.4 ps=8.7 w=4 l=0.5
X95 a_8540_8720# PHIB a_8800_8690# VN sky130_fd_pr__nfet_01v8 ad=1.5 pd=7 as=1.2 ps=6.8 w=3 l=0.5
X96 a_14980_4460# a_12380_4460# a_14520_4460# VN sky130_fd_pr__nfet_01v8 ad=0.125 pd=1.25 as=0.4 ps=2.8 w=1 l=0.5
X97 a_14980_9840# AND2_0.Y a_14520_8720# VP sky130_fd_pr__pfet_01v8 ad=0.25 pd=2.25 as=0.8 ps=4.8 w=2 l=0.5
X98 a_14980_8120# a_12380_6800# a_14520_6600# VN sky130_fd_pr__nfet_01v8 ad=0.125 pd=1.25 as=0.4 ps=2.8 w=1 l=0.5
X99 a_8210_3870# OR2_0.A a_8390_2420# VP sky130_fd_pr__pfet_01v8 ad=1.4 pd=8.7 as=0.5 ps=4.25 w=4 l=0.5
X100 VP AND2_1.Y a_12010_2540# VP sky130_fd_pr__pfet_01v8 ad=0.45 pd=2.45 as=0.8 ps=4.8 w=2 l=0.5
X101 VN DAC_B0 a_8110_4430# VN sky130_fd_pr__nfet_01v8 ad=0.2 pd=1.4 as=0.4 ps=2.8 w=1 l=0.5
X102 a_8900_200# a_8800_170# VN VN sky130_fd_pr__nfet_01v8 ad=0.4 pd=2.8 as=0.2 ps=1.4 w=1 l=0.5
X103 a_1800_200# RST_N VN VN sky130_fd_pr__nfet_01v8 ad=0.375 pd=3.25 as=1.2 ps=6.8 w=3 l=0.5
X104 VP 2_1_MUX_2.Y a_8540_8720# VP sky130_fd_pr__pfet_01v8 ad=0.4 pd=2.4 as=0.8 ps=4.8 w=2 l=0.5
X105 VN DAC_B0 a_8110_6770# VN sky130_fd_pr__nfet_01v8 ad=0.2 pd=1.4 as=0.4 ps=2.8 w=1 l=0.5
X106 a_580_200# PHIB a_1090_200# VN sky130_fd_pr__nfet_01v8 ad=1.5 pd=7 as=1.2 ps=6.8 w=3 l=0.5
X107 a_15030_8690# RST_N VP VP sky130_fd_pr__pfet_01v8 ad=0.8 pd=4.8 as=0.4 ps=2.4 w=2 l=0.5
X108 a_8030_6800# PHIB a_8800_6770# VN sky130_fd_pr__nfet_01v8 ad=1.5 pd=7 as=1.2 ps=6.8 w=3 l=0.5
X109 a_13890_4460# a_12880_4460# a_13740_4460# VN sky130_fd_pr__nfet_01v8 ad=0.375 pd=3.25 as=0.375 ps=3.25 w=3 l=0.5
X110 a_12520_8720# AND2_1.Y a_12780_8690# VN sky130_fd_pr__nfet_01v8 ad=1.5 pd=7 as=1.2 ps=6.8 w=3 l=0.5
X111 a_12780_4430# a_12010_4460# a_13890_4460# VN sky130_fd_pr__nfet_01v8 ad=1.2 pd=6.8 as=0.375 ps=3.25 w=3 l=0.5
X112 a_6970_9610# DFFR_0.D VN VN sky130_fd_pr__nfet_01v8 ad=0.45 pd=2.9 as=0.45 ps=2.9 w=1 l=0.5
X113 VP PHIB a_7520_6800# VP sky130_fd_pr__pfet_01v8 ad=0.45 pd=2.45 as=0.8 ps=4.8 w=2 l=0.5
X114 a_15030_2510# RST_N VP VP sky130_fd_pr__pfet_01v8 ad=0.8 pd=4.8 as=0.4 ps=2.4 w=2 l=0.5
X115 a_8800_6770# PHIB a_9580_6600# VP sky130_fd_pr__pfet_01v8 ad=1.615 pd=8.9 as=0.8 ps=4.4 w=4 l=0.5
X116 VN OR2_0.A a_12520_4460# VN sky130_fd_pr__nfet_01v8 ad=0.2 pd=1.4 as=0.4 ps=2.8 w=1 l=0.5
X117 VP OR2_2.A a_12520_8720# VP sky130_fd_pr__pfet_01v8 ad=0.4 pd=2.4 as=0.8 ps=4.8 w=2 l=0.5
X118 a_6460_5350# DFFR_1.Q VN VN sky130_fd_pr__nfet_01v8 ad=0.45 pd=2.9 as=0.45 ps=2.9 w=1 l=0.5
X119 a_10090_2360# PHIB VP VP sky130_fd_pr__pfet_01v8 ad=0.9 pd=4.9 as=0.45 ps=2.45 w=2 l=0.5
X120 a_12520_2540# a_12010_2540# a_12780_2510# VP sky130_fd_pr__pfet_01v8 ad=1.5 pd=7 as=1.2 ps=6.8 w=3 l=0.5
X121 VN OR2_1.A a_12520_6800# VN sky130_fd_pr__nfet_01v8 ad=0.2 pd=1.4 as=0.4 ps=2.8 w=1 l=0.5
X122 OR2_0.A a_11050_4430# VP VP sky130_fd_pr__pfet_01v8 ad=0.8 pd=4.8 as=0.4 ps=2.4 w=2 l=0.5
X123 a_13890_3460# a_12880_2540# a_13740_3460# VN sky130_fd_pr__nfet_01v8 ad=0.375 pd=3.25 as=0.375 ps=3.25 w=3 l=0.5
X124 VP RST_N a_1620_1120# VP sky130_fd_pr__pfet_01v8 ad=0.8 pd=4.4 as=1.6 ps=8.8 w=4 l=0.5
X125 a_6460_6690# DFFR_0.Q VN VN sky130_fd_pr__nfet_01v8 ad=0.45 pd=2.9 as=0.45 ps=2.9 w=1 l=0.5
X126 a_12520_6800# AND2_1.Y a_12780_6770# VN sky130_fd_pr__nfet_01v8 ad=1.5 pd=7 as=1.2 ps=6.8 w=3 l=0.5
X127 a_12780_2510# a_12010_2540# a_13890_3460# VN sky130_fd_pr__nfet_01v8 ad=1.2 pd=6.8 as=0.375 ps=3.25 w=3 l=0.5
X128 VP COMP a_9130_2360# VP sky130_fd_pr__pfet_01v8 ad=0.45 pd=2.45 as=0.9 ps=4.9 w=2 l=0.5
X129 VP a_6560_200# a_7070_170# VP sky130_fd_pr__pfet_01v8 ad=0.4 pd=2.4 as=0.8 ps=4.8 w=2 l=0.5
X130 a_7390_2420# DFFR_0.Q VP VP sky130_fd_pr__pfet_01v8 ad=0.5 pd=4.25 as=1.4 ps=8.7 w=4 l=0.5
X131 a_12380_200# PHIA VP VP sky130_fd_pr__pfet_01v8 ad=0.8 pd=4.8 as=0.45 ps=2.45 w=2 l=0.5
X132 VN RST_N a_15640_4460# VN sky130_fd_pr__nfet_01v8 ad=0.8 pd=4.8 as=0.25 ps=2.25 w=2 l=0.5
X133 a_7210_3870# OR2_1.A a_7390_2420# VP sky130_fd_pr__pfet_01v8 ad=1.4 pd=8.7 as=0.5 ps=4.25 w=4 l=0.5
X134 DAC_B1 a_8210_3870# VP VP sky130_fd_pr__pfet_01v8 ad=0.8 pd=4.8 as=0.8 ps=4.8 w=2 l=0.5
X135 a_8210_7920# a_8110_6770# VN VN sky130_fd_pr__nfet_01v8 ad=0.25 pd=2.25 as=0.8 ps=4.8 w=2 l=0.5
X136 VP a_10540_6600# a_11050_6770# VP sky130_fd_pr__pfet_01v8 ad=0.4 pd=2.4 as=0.8 ps=4.8 w=2 l=0.5
X137 a_440_200# PHIA VN VN sky130_fd_pr__nfet_01v8 ad=0.4 pd=2.8 as=0.225 ps=1.45 w=1 l=0.5
X138 a_8540_200# PHIB a_8800_170# VN sky130_fd_pr__nfet_01v8 ad=1.5 pd=7 as=1.2 ps=6.8 w=3 l=0.5
X139 VN DFFR_0.Q a_8540_200# VN sky130_fd_pr__nfet_01v8 ad=0.2 pd=1.4 as=0.4 ps=2.8 w=1 l=0.5
X140 a_7890_6800# PHIA VP VP sky130_fd_pr__pfet_01v8 ad=0.8 pd=4.8 as=0.45 ps=2.45 w=2 l=0.5
X141 VN a_11050_4430# a_11000_4460# VN sky130_fd_pr__nfet_01v8 ad=0.2 pd=1.4 as=0.125 ps=1.25 w=1 l=0.5
X142 AND2_1.Y a_10090_2360# VN VN sky130_fd_pr__nfet_01v8 ad=0.4 pd=2.8 as=0.4 ps=2.8 w=1 l=0.5
X143 VN PHIB a_12010_200# VN sky130_fd_pr__nfet_01v8 ad=0.225 pd=1.45 as=0.4 ps=2.8 w=1 l=0.5
X144 a_7680_200# a_6560_200# a_7070_170# VN sky130_fd_pr__nfet_01v8 ad=0.25 pd=2.25 as=0.8 ps=4.8 w=2 l=0.5
X145 VP a_11050_8690# a_11000_9840# VP sky130_fd_pr__pfet_01v8 ad=0.4 pd=2.4 as=0.25 ps=2.25 w=2 l=0.5
X146 a_4820_170# PHIB a_5600_1120# VP sky130_fd_pr__pfet_01v8 ad=1.615 pd=8.9 as=0.8 ps=4.4 w=4 l=0.5
X147 2_1_MUX_2.Y DFFR_0.D OR2_2.A VN sky130_fd_pr__nfet_01v8 ad=1.35 pd=6.9 as=1.35 ps=6.9 w=3 l=0.5
X148 VN a_11050_6770# a_11000_8120# VN sky130_fd_pr__nfet_01v8 ad=0.2 pd=1.4 as=0.125 ps=1.25 w=1 l=0.5
X149 a_8900_4460# a_8800_4430# VN VN sky130_fd_pr__nfet_01v8 ad=0.4 pd=2.8 as=0.2 ps=1.4 w=1 l=0.5
X150 VP a_10540_200# a_11050_170# VP sky130_fd_pr__pfet_01v8 ad=0.4 pd=2.4 as=0.8 ps=4.8 w=2 l=0.5
X151 a_8900_8720# a_8800_8690# VP VP sky130_fd_pr__pfet_01v8 ad=0.8 pd=4.8 as=0.4 ps=2.4 w=2 l=0.5
X152 a_8900_6800# a_8800_6770# VN VN sky130_fd_pr__nfet_01v8 ad=0.4 pd=2.8 as=0.2 ps=1.4 w=1 l=0.5
X153 a_12780_2510# AND2_1.Y a_13560_2340# VP sky130_fd_pr__pfet_01v8 ad=1.615 pd=8.9 as=0.8 ps=4.4 w=4 l=0.5
X154 VN a_15030_2510# a_14980_3860# VN sky130_fd_pr__nfet_01v8 ad=0.2 pd=1.4 as=0.125 ps=1.25 w=1 l=0.5
X155 a_8800_8690# a_8030_8720# a_9910_8720# VN sky130_fd_pr__nfet_01v8 ad=1.2 pd=6.8 as=0.375 ps=3.25 w=3 l=0.5
X156 a_14980_8720# a_12380_8720# a_14520_8720# VN sky130_fd_pr__nfet_01v8 ad=0.125 pd=1.25 as=0.4 ps=2.8 w=1 l=0.5
X157 a_3040_200# a_70_200# a_1090_200# VN sky130_fd_pr__nfet_01v8 ad=0.125 pd=1.25 as=0.4 ps=2.8 w=1 l=0.5
X158 VP AND2_1.Y a_12010_6800# VP sky130_fd_pr__pfet_01v8 ad=0.45 pd=2.45 as=0.8 ps=4.8 w=2 l=0.5
X159 a_11050_2360# PHIA VP VP sky130_fd_pr__pfet_01v8 ad=0.9 pd=4.9 as=0.45 ps=2.45 w=2 l=0.5
X160 a_15640_200# a_14520_200# a_15030_170# VN sky130_fd_pr__nfet_01v8 ad=0.25 pd=2.25 as=0.8 ps=4.8 w=2 l=0.5
X161 a_8800_170# PHIB a_9580_1120# VP sky130_fd_pr__pfet_01v8 ad=1.615 pd=8.9 as=0.8 ps=4.4 w=4 l=0.5
X162 a_6560_200# PHIA a_4920_200# VN sky130_fd_pr__nfet_01v8 ad=1.5 pd=7 as=1.2 ps=6.8 w=3 l=0.5
X163 VN 2_1_MUX_2.Y a_8540_8720# VN sky130_fd_pr__nfet_01v8 ad=0.2 pd=1.4 as=0.4 ps=2.8 w=1 l=0.5
X164 a_11660_7920# a_10540_6600# a_11050_6770# VN sky130_fd_pr__nfet_01v8 ad=0.25 pd=2.25 as=0.8 ps=4.8 w=2 l=0.5
X165 a_8030_6800# a_7520_6800# a_8800_6770# VP sky130_fd_pr__pfet_01v8 ad=1.5 pd=7 as=1.2 ps=6.8 w=3 l=0.5
X166 COMP a_6460_5350# 2_1_MUX_0.Y VN sky130_fd_pr__nfet_01v8 ad=1.35 pd=6.9 as=1.35 ps=6.9 w=3 l=0.5
X167 a_6390_2420# DFFR_0.D VP VP sky130_fd_pr__pfet_01v8 ad=0.5 pd=4.25 as=1.4 ps=8.7 w=4 l=0.5
X168 a_14980_2540# AND2_0.Y a_14520_2340# VP sky130_fd_pr__pfet_01v8 ad=0.25 pd=2.25 as=0.8 ps=4.8 w=2 l=0.5
X169 a_13890_8720# a_12880_8720# a_13740_8720# VN sky130_fd_pr__nfet_01v8 ad=0.375 pd=3.25 as=0.375 ps=3.25 w=3 l=0.5
X170 a_8800_6770# a_7520_6800# a_9910_7720# VN sky130_fd_pr__nfet_01v8 ad=1.2 pd=6.8 as=0.375 ps=3.25 w=3 l=0.5
X171 VN RST_N a_11660_7920# VN sky130_fd_pr__nfet_01v8 ad=0.8 pd=4.8 as=0.25 ps=2.25 w=2 l=0.5
X172 VP RST_N a_9580_5380# VP sky130_fd_pr__pfet_01v8 ad=0.8 pd=4.4 as=1.6 ps=8.8 w=4 l=0.5
X173 a_6210_3870# OR2_2.A a_6390_2420# VP sky130_fd_pr__pfet_01v8 ad=1.4 pd=8.7 as=0.5 ps=4.25 w=4 l=0.5
X174 DAC_B2 a_7210_3870# VP VP sky130_fd_pr__pfet_01v8 ad=0.8 pd=4.8 as=0.8 ps=4.8 w=2 l=0.5
X175 VP a_15030_4430# a_14980_5580# VP sky130_fd_pr__pfet_01v8 ad=0.4 pd=2.4 as=0.25 ps=2.25 w=2 l=0.5
X176 a_7070_170# RST_N VP VP sky130_fd_pr__pfet_01v8 ad=0.8 pd=4.8 as=0.4 ps=2.4 w=2 l=0.5
X177 a_12780_8690# a_12010_8720# a_13890_8720# VN sky130_fd_pr__nfet_01v8 ad=1.2 pd=6.8 as=0.375 ps=3.25 w=3 l=0.5
X178 a_11000_200# a_8400_200# a_10540_200# VN sky130_fd_pr__nfet_01v8 ad=0.125 pd=1.25 as=0.4 ps=2.8 w=1 l=0.5
X179 COMP DFFR_0.Q 2_1_MUX_1.Y VP sky130_fd_pr__pfet_01v8 ad=1.35 pd=6.9 as=1.35 ps=6.9 w=3 l=0.5
X180 a_11050_6770# RST_N VP VP sky130_fd_pr__pfet_01v8 ad=0.8 pd=4.8 as=0.4 ps=2.4 w=2 l=0.5
X181 AND2_0.Y a_11050_2360# VN VN sky130_fd_pr__nfet_01v8 ad=0.4 pd=2.8 as=0.4 ps=2.8 w=1 l=0.5
X182 a_14520_200# a_12380_200# a_12880_200# VP sky130_fd_pr__pfet_01v8 ad=1.5 pd=7 as=1.2 ps=6.8 w=3 l=0.5
X183 VN OR2_2.A a_12520_8720# VN sky130_fd_pr__nfet_01v8 ad=0.2 pd=1.4 as=0.4 ps=2.8 w=1 l=0.5
X184 a_14520_200# PHIA a_12880_200# VN sky130_fd_pr__nfet_01v8 ad=1.5 pd=7 as=1.2 ps=6.8 w=3 l=0.5
X185 a_13890_7720# a_12880_6800# a_13740_7720# VN sky130_fd_pr__nfet_01v8 ad=0.375 pd=3.25 as=0.375 ps=3.25 w=3 l=0.5
X186 a_12520_6800# a_12010_6800# a_12780_6770# VP sky130_fd_pr__pfet_01v8 ad=1.5 pd=7 as=1.2 ps=6.8 w=3 l=0.5
X187 OR2_0.A a_11050_4430# VN VN sky130_fd_pr__nfet_01v8 ad=0.4 pd=2.8 as=0.2 ps=1.4 w=1 l=0.5
X188 a_12880_2540# a_12780_2510# VN VN sky130_fd_pr__nfet_01v8 ad=0.4 pd=2.8 as=0.2 ps=1.4 w=1 l=0.5
X189 VP DFFR_0.D a_4560_200# VP sky130_fd_pr__pfet_01v8 ad=0.4 pd=2.4 as=0.8 ps=4.8 w=2 l=0.5
X190 OR2_2.A a_11050_8690# VP VP sky130_fd_pr__pfet_01v8 ad=0.8 pd=4.8 as=0.4 ps=2.4 w=2 l=0.5
X191 OR2_1.A a_11050_6770# VN VN sky130_fd_pr__nfet_01v8 ad=0.4 pd=2.8 as=0.2 ps=1.4 w=1 l=0.5
X192 a_8030_6800# 2_1_MUX_1.Y VP VP sky130_fd_pr__pfet_01v8 ad=0.8 pd=4.8 as=0.4 ps=2.4 w=2 l=0.5
X193 a_12780_6770# a_12010_6800# a_13890_7720# VN sky130_fd_pr__nfet_01v8 ad=1.2 pd=6.8 as=0.375 ps=3.25 w=3 l=0.5
X194 VP RST_N a_13560_5380# VP sky130_fd_pr__pfet_01v8 ad=0.8 pd=4.4 as=1.6 ps=8.8 w=4 l=0.5
X195 a_11050_170# RST_N VP VP sky130_fd_pr__pfet_01v8 ad=0.8 pd=4.8 as=0.4 ps=2.4 w=2 l=0.5
X196 DFFR_0.D a_940_200# VN VN sky130_fd_pr__nfet_01v8 ad=0.4 pd=2.8 as=0.2 ps=1.4 w=1 l=0.5
X197 VP AND2_2.Y a_12520_2540# VP sky130_fd_pr__pfet_01v8 ad=0.4 pd=2.4 as=0.8 ps=4.8 w=2 l=0.5
X198 VN RST_N a_15640_8720# VN sky130_fd_pr__nfet_01v8 ad=0.8 pd=4.8 as=0.25 ps=2.25 w=2 l=0.5
X199 VP DAC_B0 a_10090_2360# VP sky130_fd_pr__pfet_01v8 ad=0.45 pd=2.45 as=0.9 ps=4.9 w=2 l=0.5
X200 a_15640_3660# a_14520_2340# a_15030_2510# VN sky130_fd_pr__nfet_01v8 ad=0.25 pd=2.25 as=0.8 ps=4.8 w=2 l=0.5
X201 VN RST_N a_3700_200# VN sky130_fd_pr__nfet_01v8 ad=0.8 pd=4.8 as=0.25 ps=2.25 w=2 l=0.5
X202 2_1_MUX_0.Y a_6460_5350# OR2_0.A VP sky130_fd_pr__pfet_01v8 ad=1.35 pd=6.9 as=1.35 ps=6.9 w=3 l=0.5
X203 ADC_OUT_B0 a_15030_2510# VN VN sky130_fd_pr__nfet_01v8 ad=0.4 pd=2.8 as=0.2 ps=1.4 w=1 l=0.5
X204 VN a_11050_8690# a_11000_8720# VN sky130_fd_pr__nfet_01v8 ad=0.2 pd=1.4 as=0.125 ps=1.25 w=1 l=0.5
X205 a_12880_4460# a_12780_4430# VP VP sky130_fd_pr__pfet_01v8 ad=0.8 pd=4.8 as=0.4 ps=2.4 w=2 l=0.5
X206 a_12880_200# a_12780_170# VN VN sky130_fd_pr__nfet_01v8 ad=0.4 pd=2.8 as=0.2 ps=1.4 w=1 l=0.5
X207 VP PHIB a_12010_200# VP sky130_fd_pr__pfet_01v8 ad=0.45 pd=2.45 as=0.8 ps=4.8 w=2 l=0.5
X208 a_8900_8720# a_8800_8690# VN VN sky130_fd_pr__nfet_01v8 ad=0.4 pd=2.8 as=0.2 ps=1.4 w=1 l=0.5
X209 VP a_10540_4460# a_11050_4430# VP sky130_fd_pr__pfet_01v8 ad=0.4 pd=2.4 as=0.8 ps=4.8 w=2 l=0.5
X210 DAC_B3 a_6210_3870# VP VP sky130_fd_pr__pfet_01v8 ad=0.8 pd=4.8 as=0.8 ps=4.8 w=2 l=0.5
X211 VP a_2580_200# a_3040_1320# VP sky130_fd_pr__pfet_01v8 ad=0.4 pd=2.4 as=0.25 ps=2.25 w=2 l=0.5
X212 a_12780_6770# AND2_1.Y a_13560_6600# VP sky130_fd_pr__pfet_01v8 ad=1.615 pd=8.9 as=0.8 ps=4.4 w=4 l=0.5
X213 DFFR_1.Q a_11050_170# VN VN sky130_fd_pr__nfet_01v8 ad=0.4 pd=2.8 as=0.2 ps=1.4 w=1 l=0.5
X214 a_5780_200# RST_N VN VN sky130_fd_pr__nfet_01v8 ad=0.375 pd=3.25 as=1.2 ps=6.8 w=3 l=0.5
X215 a_8030_5580# a_7520_4460# a_8800_4430# VP sky130_fd_pr__pfet_01v8 ad=1.5 pd=7 as=1.2 ps=6.8 w=3 l=0.5
X216 a_9580_5380# a_8900_4460# VP VP sky130_fd_pr__pfet_01v8 ad=0.8 pd=4.4 as=0.8 ps=4.4 w=4 l=0.5
X217 ADC_OUT_B1 a_15030_4430# VP VP sky130_fd_pr__pfet_01v8 ad=0.8 pd=4.8 as=0.4 ps=2.4 w=2 l=0.5
X218 VN RST_N a_11660_200# VN sky130_fd_pr__nfet_01v8 ad=0.8 pd=4.8 as=0.25 ps=2.25 w=2 l=0.5
X219 a_9320_3660# COMP VN VN sky130_fd_pr__nfet_01v8 ad=0.25 pd=2.25 as=0.8 ps=4.8 w=2 l=0.5
X220 VN PHIB a_4050_200# VN sky130_fd_pr__nfet_01v8 ad=0.225 pd=1.45 as=0.4 ps=2.8 w=1 l=0.5
X221 VN a_2580_200# a_3040_200# VN sky130_fd_pr__nfet_01v8 ad=0.2 pd=1.4 as=0.125 ps=1.25 w=1 l=0.5
X222 a_14980_6800# AND2_0.Y a_14520_6600# VP sky130_fd_pr__pfet_01v8 ad=0.25 pd=2.25 as=0.8 ps=4.8 w=2 l=0.5
X223 VP a_14520_6600# a_15030_6770# VP sky130_fd_pr__pfet_01v8 ad=0.4 pd=2.4 as=0.8 ps=4.8 w=2 l=0.5
X224 a_4920_200# a_4820_170# VP VP sky130_fd_pr__pfet_01v8 ad=0.8 pd=4.8 as=0.4 ps=2.4 w=2 l=0.5
X225 a_8400_8720# PHIA VP VP sky130_fd_pr__pfet_01v8 ad=0.8 pd=4.8 as=0.45 ps=2.45 w=2 l=0.5
X226 VN a_15030_4430# a_14980_4460# VN sky130_fd_pr__nfet_01v8 ad=0.2 pd=1.4 as=0.125 ps=1.25 w=1 l=0.5
X227 AND2_2.Y a_9130_2360# VP VP sky130_fd_pr__pfet_01v8 ad=0.804 pd=4.82 as=0.804 ps=4.82 w=2.01 l=0.5
X228 VP RST_N a_9580_9640# VP sky130_fd_pr__pfet_01v8 ad=0.8 pd=4.4 as=1.6 ps=8.8 w=4 l=0.5
X229 VP a_15030_8690# a_14980_9840# VP sky130_fd_pr__pfet_01v8 ad=0.4 pd=2.4 as=0.25 ps=2.25 w=2 l=0.5
X230 VP DAC_B0 a_8110_6770# VP sky130_fd_pr__pfet_01v8 ad=0.4 pd=2.4 as=0.8 ps=4.8 w=2 l=0.5
X231 a_12520_4460# a_12010_4460# a_12780_4430# VP sky130_fd_pr__pfet_01v8 ad=1.5 pd=7 as=1.2 ps=6.8 w=3 l=0.5
X232 a_13560_5380# a_12880_4460# VP VP sky130_fd_pr__pfet_01v8 ad=0.8 pd=4.4 as=0.8 ps=4.4 w=4 l=0.5
X233 VP DAC_B0 a_11050_2360# VP sky130_fd_pr__pfet_01v8 ad=0.45 pd=2.45 as=0.9 ps=4.9 w=2 l=0.5
X234 a_13740_200# RST_N VN VN sky130_fd_pr__nfet_01v8 ad=0.375 pd=3.25 as=1.2 ps=6.8 w=3 l=0.5
X235 VN a_15030_6770# a_14980_8120# VN sky130_fd_pr__nfet_01v8 ad=0.2 pd=1.4 as=0.125 ps=1.25 w=1 l=0.5
X236 a_11000_5580# PHIA a_10540_4460# VP sky130_fd_pr__pfet_01v8 ad=0.25 pd=2.25 as=0.8 ps=4.8 w=2 l=0.5
X237 VP DAC_B0 a_580_200# VP sky130_fd_pr__pfet_01v8 ad=0.4 pd=2.4 as=0.8 ps=4.8 w=2 l=0.5
X238 VP a_14520_200# a_15030_170# VP sky130_fd_pr__pfet_01v8 ad=0.4 pd=2.4 as=0.8 ps=4.8 w=2 l=0.5
X239 a_8030_6800# 2_1_MUX_1.Y a_8210_7920# VN sky130_fd_pr__nfet_01v8 ad=0.8 pd=4.8 as=0.25 ps=2.25 w=2 l=0.5
X240 COMP a_6460_6690# 2_1_MUX_1.Y VN sky130_fd_pr__nfet_01v8 ad=1.35 pd=6.9 as=1.35 ps=6.9 w=3 l=0.5
X241 VP a_8110_4430# a_8030_5580# VP sky130_fd_pr__pfet_01v8 ad=0.4 pd=2.4 as=0.8 ps=4.8 w=2 l=0.5
X242 a_10540_4460# a_7890_4460# a_8900_4460# VP sky130_fd_pr__pfet_01v8 ad=1.5 pd=7 as=1.2 ps=6.8 w=3 l=0.5
X243 VN a_11050_170# a_11000_200# VN sky130_fd_pr__nfet_01v8 ad=0.2 pd=1.4 as=0.125 ps=1.25 w=1 l=0.5
X244 OR2_2.A a_11050_8690# VN VN sky130_fd_pr__nfet_01v8 ad=0.4 pd=2.8 as=0.2 ps=1.4 w=1 l=0.5
X245 VN DFFR_1.Q a_8210_3870# VN sky130_fd_pr__nfet_01v8 ad=0.2 pd=1.4 as=0.4 ps=2.8 w=1 l=0.5
X246 DFFR_0.D a_940_200# VP VP sky130_fd_pr__pfet_01v8 ad=0.8 pd=4.8 as=0.4 ps=2.4 w=2 l=0.5
X247 VP RST_N a_13560_9640# VP sky130_fd_pr__pfet_01v8 ad=0.8 pd=4.4 as=1.6 ps=8.8 w=4 l=0.5
X248 VP OR2_1.A a_12520_6800# VP sky130_fd_pr__pfet_01v8 ad=0.4 pd=2.4 as=0.8 ps=4.8 w=2 l=0.5
X249 a_11050_4430# RST_N VP VP sky130_fd_pr__pfet_01v8 ad=0.8 pd=4.8 as=0.4 ps=2.4 w=2 l=0.5
X250 a_12780_170# PHIB a_13560_1120# VP sky130_fd_pr__pfet_01v8 ad=1.615 pd=8.9 as=0.8 ps=4.4 w=4 l=0.5
X251 a_4820_170# a_4050_200# a_5930_200# VN sky130_fd_pr__nfet_01v8 ad=1.2 pd=6.8 as=0.375 ps=3.25 w=3 l=0.5
X252 a_6460_6690# DFFR_0.Q VP VP sky130_fd_pr__pfet_01v8 ad=0.9 pd=4.9 as=0.9 ps=4.9 w=2 l=0.5
X253 a_15640_7920# a_14520_6600# a_15030_6770# VN sky130_fd_pr__nfet_01v8 ad=0.25 pd=2.25 as=0.8 ps=4.8 w=2 l=0.5
X254 a_12880_4460# a_12780_4430# VN VN sky130_fd_pr__nfet_01v8 ad=0.4 pd=2.8 as=0.2 ps=1.4 w=1 l=0.5
X255 a_12880_8720# a_12780_8690# VP VP sky130_fd_pr__pfet_01v8 ad=0.8 pd=4.8 as=0.4 ps=2.4 w=2 l=0.5
X256 a_12880_6800# a_12780_6770# VN VN sky130_fd_pr__nfet_01v8 ad=0.4 pd=2.8 as=0.2 ps=1.4 w=1 l=0.5
X257 a_12380_2540# AND2_0.Y VN VN sky130_fd_pr__nfet_01v8 ad=0.4 pd=2.8 as=0.225 ps=1.45 w=1 l=0.5
X258 a_580_200# a_70_200# a_1090_200# VP sky130_fd_pr__pfet_01v8 ad=1.5 pd=7 as=1.2 ps=6.8 w=3 l=0.5
X259 a_1620_1120# a_940_200# VP VP sky130_fd_pr__pfet_01v8 ad=0.8 pd=4.4 as=0.8 ps=4.4 w=4 l=0.5
X260 VN PHIB a_70_200# VN sky130_fd_pr__nfet_01v8 ad=0.225 pd=1.45 as=0.4 ps=2.8 w=1 l=0.5
X261 a_1950_200# a_940_200# a_1800_200# VN sky130_fd_pr__nfet_01v8 ad=0.375 pd=3.25 as=0.375 ps=3.25 w=3 l=0.5
X262 a_15030_6770# RST_N VP VP sky130_fd_pr__pfet_01v8 ad=0.8 pd=4.8 as=0.4 ps=2.4 w=2 l=0.5
X263 a_14980_1320# PHIA a_14520_200# VP sky130_fd_pr__pfet_01v8 ad=0.25 pd=2.25 as=0.8 ps=4.8 w=2 l=0.5
X264 VP a_11050_6770# a_11000_6800# VP sky130_fd_pr__pfet_01v8 ad=0.4 pd=2.4 as=0.25 ps=2.25 w=2 l=0.5
X265 a_12780_170# a_12010_200# a_13890_200# VN sky130_fd_pr__nfet_01v8 ad=1.2 pd=6.8 as=0.375 ps=3.25 w=3 l=0.5
X266 a_8540_8720# a_8030_8720# a_8800_8690# VP sky130_fd_pr__pfet_01v8 ad=1.5 pd=7 as=1.2 ps=6.8 w=3 l=0.5
X267 a_9580_9640# a_8900_8720# VP VP sky130_fd_pr__pfet_01v8 ad=0.8 pd=4.4 as=0.8 ps=4.4 w=4 l=0.5
X268 ADC_OUT_B1 a_15030_4430# VN VN sky130_fd_pr__nfet_01v8 ad=0.4 pd=2.8 as=0.2 ps=1.4 w=1 l=0.5
X269 VP DFFR_0.Q a_8540_200# VP sky130_fd_pr__pfet_01v8 ad=0.4 pd=2.4 as=0.8 ps=4.8 w=2 l=0.5
X270 ADC_OUT_B3 a_15030_8690# VP VP sky130_fd_pr__pfet_01v8 ad=0.8 pd=4.8 as=0.4 ps=2.4 w=2 l=0.5
X271 a_8900_6800# a_8800_6770# VP VP sky130_fd_pr__pfet_01v8 ad=0.8 pd=4.8 as=0.4 ps=2.4 w=2 l=0.5
X272 ADC_OUT_B2 a_15030_6770# VN VN sky130_fd_pr__nfet_01v8 ad=0.4 pd=2.8 as=0.2 ps=1.4 w=1 l=0.5
X273 a_940_200# a_840_170# VP VP sky130_fd_pr__pfet_01v8 ad=0.8 pd=4.8 as=0.4 ps=2.4 w=2 l=0.5
X274 a_15030_170# RST_N VP VP sky130_fd_pr__pfet_01v8 ad=0.8 pd=4.8 as=0.4 ps=2.4 w=2 l=0.5
X275 VN DFFR_0.Q a_7210_3870# VN sky130_fd_pr__nfet_01v8 ad=0.2 pd=1.4 as=0.4 ps=2.8 w=1 l=0.5
X276 a_10280_3660# DAC_B0 VN VN sky130_fd_pr__nfet_01v8 ad=0.25 pd=2.25 as=0.8 ps=4.8 w=2 l=0.5
X277 a_4920_200# a_4820_170# VN VN sky130_fd_pr__nfet_01v8 ad=0.4 pd=2.8 as=0.2 ps=1.4 w=1 l=0.5
X278 a_10540_6600# a_7890_6800# a_8900_6800# VP sky130_fd_pr__pfet_01v8 ad=1.5 pd=7 as=1.2 ps=6.8 w=3 l=0.5
X279 2_1_MUX_0.Y DFFR_1.Q OR2_0.A VN sky130_fd_pr__nfet_01v8 ad=1.35 pd=6.9 as=1.35 ps=6.9 w=3 l=0.5
X280 a_12380_4460# AND2_0.Y VP VP sky130_fd_pr__pfet_01v8 ad=0.8 pd=4.8 as=0.45 ps=2.45 w=2 l=0.5
X281 a_14980_200# a_12380_200# a_14520_200# VN sky130_fd_pr__nfet_01v8 ad=0.125 pd=1.25 as=0.4 ps=2.8 w=1 l=0.5
X282 a_10090_2360# PHIB a_10280_3660# VN sky130_fd_pr__nfet_01v8 ad=0.8 pd=4.8 as=0.25 ps=2.25 w=2 l=0.5
X283 a_8400_8720# PHIA VN VN sky130_fd_pr__nfet_01v8 ad=0.4 pd=2.8 as=0.225 ps=1.45 w=1 l=0.5
X284 a_8210_3870# OR2_0.A VN VN sky130_fd_pr__nfet_01v8 ad=0.4 pd=2.8 as=0.2 ps=1.4 w=1 l=0.5
X285 a_12520_8720# a_12010_8720# a_12780_8690# VP sky130_fd_pr__pfet_01v8 ad=1.5 pd=7 as=1.2 ps=6.8 w=3 l=0.5
X286 a_13560_9640# a_12880_8720# VP VP sky130_fd_pr__pfet_01v8 ad=0.8 pd=4.4 as=0.8 ps=4.4 w=4 l=0.5
X287 VN a_15030_8690# a_14980_8720# VN sky130_fd_pr__nfet_01v8 ad=0.2 pd=1.4 as=0.125 ps=1.25 w=1 l=0.5
X288 a_11000_4460# a_7890_4460# a_10540_4460# VN sky130_fd_pr__nfet_01v8 ad=0.125 pd=1.25 as=0.4 ps=2.8 w=1 l=0.5
X289 VN RST_N a_15640_3660# VN sky130_fd_pr__nfet_01v8 ad=0.8 pd=4.8 as=0.25 ps=2.25 w=2 l=0.5
X290 VP DFFR_1.Q a_12520_200# VP sky130_fd_pr__pfet_01v8 ad=0.4 pd=2.4 as=0.8 ps=4.8 w=2 l=0.5
X291 a_11000_9840# PHIA a_10540_8720# VP sky130_fd_pr__pfet_01v8 ad=0.25 pd=2.25 as=0.8 ps=4.8 w=2 l=0.5
X292 VP a_14520_4460# a_15030_4430# VP sky130_fd_pr__pfet_01v8 ad=0.4 pd=2.4 as=0.8 ps=4.8 w=2 l=0.5
X293 AND2_1.Y a_10090_2360# VP VP sky130_fd_pr__pfet_01v8 ad=0.804 pd=4.82 as=0.804 ps=4.82 w=2.01 l=0.5
X294 a_8400_200# PHIA VN VN sky130_fd_pr__nfet_01v8 ad=0.4 pd=2.8 as=0.225 ps=1.45 w=1 l=0.5
X295 VP a_7070_170# a_7020_1320# VP sky130_fd_pr__pfet_01v8 ad=0.4 pd=2.4 as=0.25 ps=2.25 w=2 l=0.5
X296 2_1_MUX_1.Y a_6460_6690# OR2_1.A VP sky130_fd_pr__pfet_01v8 ad=1.35 pd=6.9 as=1.35 ps=6.9 w=3 l=0.5
X297 a_11000_8120# a_7890_6800# a_10540_6600# VN sky130_fd_pr__nfet_01v8 ad=0.125 pd=1.25 as=0.4 ps=2.8 w=1 l=0.5
X298 a_8210_4460# a_8110_4430# VN VN sky130_fd_pr__nfet_01v8 ad=0.25 pd=2.25 as=0.8 ps=4.8 w=2 l=0.5
X299 a_9910_200# a_8900_200# a_9760_200# VN sky130_fd_pr__nfet_01v8 ad=0.375 pd=3.25 as=0.375 ps=3.25 w=3 l=0.5
X300 VP PHIB a_8030_8720# VP sky130_fd_pr__pfet_01v8 ad=0.45 pd=2.45 as=0.8 ps=4.8 w=2 l=0.5
X301 a_10540_4460# PHIA a_8900_4460# VN sky130_fd_pr__nfet_01v8 ad=1.5 pd=7 as=1.2 ps=6.8 w=3 l=0.5
X302 VP a_15030_2510# a_14980_2540# VP sky130_fd_pr__pfet_01v8 ad=0.4 pd=2.4 as=0.25 ps=2.25 w=2 l=0.5
X303 a_10540_8720# a_8400_8720# a_8900_8720# VP sky130_fd_pr__pfet_01v8 ad=1.5 pd=7 as=1.2 ps=6.8 w=3 l=0.5
X304 VP PHIB a_7520_4460# VP sky130_fd_pr__pfet_01v8 ad=0.45 pd=2.45 as=0.8 ps=4.8 w=2 l=0.5
X305 VP RST_N a_5600_1120# VP sky130_fd_pr__pfet_01v8 ad=0.8 pd=4.4 as=1.6 ps=8.8 w=4 l=0.5
X306 a_4420_200# PHIA VP VP sky130_fd_pr__pfet_01v8 ad=0.8 pd=4.8 as=0.45 ps=2.45 w=2 l=0.5
X307 OR2_1.A a_11050_6770# VP VP sky130_fd_pr__pfet_01v8 ad=0.8 pd=4.8 as=0.4 ps=2.4 w=2 l=0.5
X308 a_8800_4430# PHIB a_9580_5380# VP sky130_fd_pr__pfet_01v8 ad=1.615 pd=8.9 as=0.8 ps=4.4 w=4 l=0.5
X309 a_14520_2340# a_12380_2540# a_12880_2540# VP sky130_fd_pr__pfet_01v8 ad=1.5 pd=7 as=1.2 ps=6.8 w=3 l=0.5
X310 VP a_11050_170# a_11000_1320# VP sky130_fd_pr__pfet_01v8 ad=0.4 pd=2.4 as=0.25 ps=2.25 w=2 l=0.5
X311 a_4560_200# PHIB a_4820_170# VN sky130_fd_pr__nfet_01v8 ad=1.5 pd=7 as=1.2 ps=6.8 w=3 l=0.5
X312 VN DFFR_0.D a_4560_200# VN sky130_fd_pr__nfet_01v8 ad=0.2 pd=1.4 as=0.4 ps=2.8 w=1 l=0.5
X313 VN DFFR_0.D a_6210_3870# VN sky130_fd_pr__nfet_01v8 ad=0.2 pd=1.4 as=0.4 ps=2.8 w=1 l=0.5
X314 a_9130_2360# DAC_B0 a_9320_3660# VN sky130_fd_pr__nfet_01v8 ad=0.8 pd=4.8 as=0.25 ps=2.25 w=2 l=0.5
X315 VP RST_N a_13560_2340# VP sky130_fd_pr__pfet_01v8 ad=0.8 pd=4.4 as=1.6 ps=8.8 w=4 l=0.5
X316 a_8900_200# a_8800_170# VP VP sky130_fd_pr__pfet_01v8 ad=0.8 pd=4.8 as=0.4 ps=2.4 w=2 l=0.5
X317 a_12880_8720# a_12780_8690# VN VN sky130_fd_pr__nfet_01v8 ad=0.4 pd=2.8 as=0.2 ps=1.4 w=1 l=0.5
X318 a_7210_3870# OR2_1.A VN VN sky130_fd_pr__nfet_01v8 ad=0.4 pd=2.8 as=0.2 ps=1.4 w=1 l=0.5
X319 a_11240_3660# DAC_B0 VN VN sky130_fd_pr__nfet_01v8 ad=0.25 pd=2.25 as=0.8 ps=4.8 w=2 l=0.5
X320 VN RST_N a_15640_200# VN sky130_fd_pr__nfet_01v8 ad=0.8 pd=4.8 as=0.25 ps=2.25 w=2 l=0.5
X321 COMP DFFR_0.D 2_1_MUX_2.Y VP sky130_fd_pr__pfet_01v8 ad=1.35 pd=6.9 as=1.35 ps=6.9 w=3 l=0.5
X322 a_11660_4460# a_10540_4460# a_11050_4430# VN sky130_fd_pr__nfet_01v8 ad=0.25 pd=2.25 as=0.8 ps=4.8 w=2 l=0.5
X323 VP a_1090_200# a_2580_200# VP sky130_fd_pr__pfet_01v8 ad=0.4 pd=2.4 as=0.8 ps=4.8 w=2 l=0.5
X324 a_12880_2540# a_12780_2510# VP VP sky130_fd_pr__pfet_01v8 ad=0.8 pd=4.8 as=0.4 ps=2.4 w=2 l=0.5
X325 a_940_200# a_840_170# VN VN sky130_fd_pr__nfet_01v8 ad=0.4 pd=2.8 as=0.2 ps=1.4 w=1 l=0.5
X326 VN RST_N a_11660_4460# VN sky130_fd_pr__nfet_01v8 ad=0.8 pd=4.8 as=0.25 ps=2.25 w=2 l=0.5
X327 a_14520_4460# a_12380_4460# a_12880_4460# VP sky130_fd_pr__pfet_01v8 ad=1.5 pd=7 as=1.2 ps=6.8 w=3 l=0.5
X328 ADC_OUT_B3 a_15030_8690# VN VN sky130_fd_pr__nfet_01v8 ad=0.4 pd=2.8 as=0.2 ps=1.4 w=1 l=0.5
X329 a_7890_4460# PHIA VP VP sky130_fd_pr__pfet_01v8 ad=0.8 pd=4.8 as=0.45 ps=2.45 w=2 l=0.5
X330 AND2_0.Y a_11050_2360# VP VP sky130_fd_pr__pfet_01v8 ad=0.804 pd=4.82 as=0.804 ps=4.82 w=2.01 l=0.5
X331 a_12520_200# PHIB a_12780_170# VN sky130_fd_pr__nfet_01v8 ad=1.5 pd=7 as=1.2 ps=6.8 w=3 l=0.5
X332 VN DFFR_1.Q a_12520_200# VN sky130_fd_pr__nfet_01v8 ad=0.2 pd=1.4 as=0.4 ps=2.8 w=1 l=0.5
X333 VN AND2_1.Y a_12010_2540# VN sky130_fd_pr__nfet_01v8 ad=0.225 pd=1.45 as=0.4 ps=2.8 w=1 l=0.5
X334 a_11660_200# a_10540_200# a_11050_170# VN sky130_fd_pr__nfet_01v8 ad=0.25 pd=2.25 as=0.8 ps=4.8 w=2 l=0.5
X335 DFFR_0.Q a_7070_170# VP VP sky130_fd_pr__pfet_01v8 ad=0.8 pd=4.8 as=0.4 ps=2.4 w=2 l=0.5
X336 a_2580_200# PHIA a_840_170# VN sky130_fd_pr__nfet_01v8 ad=1.5 pd=7 as=1.2 ps=6.8 w=3 l=0.5
X337 a_15030_4430# RST_N VP VP sky130_fd_pr__pfet_01v8 ad=0.8 pd=4.8 as=0.4 ps=2.4 w=2 l=0.5
X338 a_12380_4460# AND2_0.Y VN VN sky130_fd_pr__nfet_01v8 ad=0.4 pd=2.8 as=0.225 ps=1.45 w=1 l=0.5
X339 a_12380_8720# AND2_0.Y VP VP sky130_fd_pr__pfet_01v8 ad=0.8 pd=4.8 as=0.45 ps=2.45 w=2 l=0.5
X340 ADC_OUT_B0 a_15030_2510# VP VP sky130_fd_pr__pfet_01v8 ad=0.8 pd=4.8 as=0.4 ps=2.4 w=2 l=0.5
X341 a_12380_6800# AND2_0.Y VN VN sky130_fd_pr__nfet_01v8 ad=0.4 pd=2.8 as=0.225 ps=1.45 w=1 l=0.5
X342 a_11000_8720# a_8400_8720# a_10540_8720# VN sky130_fd_pr__nfet_01v8 ad=0.125 pd=1.25 as=0.4 ps=2.8 w=1 l=0.5
X343 VN RST_N a_15640_7920# VN sky130_fd_pr__nfet_01v8 ad=0.8 pd=4.8 as=0.25 ps=2.25 w=2 l=0.5
X344 VP AND2_1.Y a_12010_4460# VP sky130_fd_pr__pfet_01v8 ad=0.45 pd=2.45 as=0.8 ps=4.8 w=2 l=0.5
X345 DFFR_1.Q a_11050_170# VP VP sky130_fd_pr__pfet_01v8 ad=0.8 pd=4.8 as=0.4 ps=2.4 w=2 l=0.5
X346 a_5600_1120# a_4920_200# VP VP sky130_fd_pr__pfet_01v8 ad=0.8 pd=4.4 as=0.8 ps=4.4 w=4 l=0.5
X347 a_4560_200# a_4050_200# a_4820_170# VP sky130_fd_pr__pfet_01v8 ad=1.5 pd=7 as=1.2 ps=6.8 w=3 l=0.5
X348 2_1_MUX_1.Y DFFR_0.Q OR2_1.A VN sky130_fd_pr__nfet_01v8 ad=1.35 pd=6.9 as=1.35 ps=6.9 w=3 l=0.5
X349 VP RST_N a_9580_6600# VP sky130_fd_pr__pfet_01v8 ad=0.8 pd=4.4 as=1.6 ps=8.8 w=4 l=0.5
X350 a_6210_3870# OR2_2.A VN VN sky130_fd_pr__nfet_01v8 ad=0.4 pd=2.8 as=0.2 ps=1.4 w=1 l=0.5
X351 a_13560_2340# a_12880_2540# VP VP sky130_fd_pr__pfet_01v8 ad=0.8 pd=4.4 as=0.8 ps=4.4 w=4 l=0.5
X352 a_3040_1320# PHIB a_1090_200# VP sky130_fd_pr__pfet_01v8 ad=0.25 pd=2.25 as=0.8 ps=4.8 w=2 l=0.5
X353 a_10540_200# PHIA a_8900_200# VN sky130_fd_pr__nfet_01v8 ad=1.5 pd=7 as=1.2 ps=6.8 w=3 l=0.5
X354 VP a_10540_8720# a_11050_8690# VP sky130_fd_pr__pfet_01v8 ad=0.4 pd=2.4 as=0.8 ps=4.8 w=2 l=0.5
X355 VN PHIB a_8030_8720# VN sky130_fd_pr__nfet_01v8 ad=0.225 pd=1.45 as=0.4 ps=2.8 w=1 l=0.5
X356 a_10540_8720# PHIA a_8900_8720# VN sky130_fd_pr__nfet_01v8 ad=1.5 pd=7 as=1.2 ps=6.8 w=3 l=0.5
X357 VP a_15030_6770# a_14980_6800# VP sky130_fd_pr__pfet_01v8 ad=0.4 pd=2.4 as=0.25 ps=2.25 w=2 l=0.5
X358 a_440_200# PHIA VP VP sky130_fd_pr__pfet_01v8 ad=0.8 pd=4.8 as=0.45 ps=2.45 w=2 l=0.5
X359 VN DAC_B0 a_580_200# VN sky130_fd_pr__nfet_01v8 ad=0.2 pd=1.4 as=0.4 ps=2.8 w=1 l=0.5
X360 a_2580_200# a_440_200# a_840_170# VP sky130_fd_pr__pfet_01v8 ad=1.5 pd=7 as=1.2 ps=6.8 w=3 l=0.5
X361 a_7020_200# a_4420_200# a_6560_200# VN sky130_fd_pr__nfet_01v8 ad=0.125 pd=1.25 as=0.4 ps=2.8 w=1 l=0.5
X362 VN PHIB a_7520_4460# VN sky130_fd_pr__nfet_01v8 ad=0.225 pd=1.45 as=0.4 ps=2.8 w=1 l=0.5
X363 VN PHIB a_7520_6800# VN sky130_fd_pr__nfet_01v8 ad=0.225 pd=1.45 as=0.4 ps=2.8 w=1 l=0.5
X364 a_14520_6600# a_12380_6800# a_12880_6800# VP sky130_fd_pr__pfet_01v8 ad=1.5 pd=7 as=1.2 ps=6.8 w=3 l=0.5
X365 DAC_B1 a_8210_3870# VN VN sky130_fd_pr__nfet_01v8 ad=0.4 pd=2.8 as=0.4 ps=2.8 w=1 l=0.5
X366 a_8800_8690# PHIB a_9580_9640# VP sky130_fd_pr__pfet_01v8 ad=1.615 pd=8.9 as=0.8 ps=4.4 w=4 l=0.5
X367 a_10540_6600# PHIA a_8900_6800# VN sky130_fd_pr__nfet_01v8 ad=1.5 pd=7 as=1.2 ps=6.8 w=3 l=0.5
X368 VP RST_N a_13560_6600# VP sky130_fd_pr__pfet_01v8 ad=0.8 pd=4.4 as=1.6 ps=8.8 w=4 l=0.5
X369 a_9760_4460# RST_N VN VN sky130_fd_pr__nfet_01v8 ad=0.375 pd=3.25 as=1.2 ps=6.8 w=3 l=0.5
.ends
