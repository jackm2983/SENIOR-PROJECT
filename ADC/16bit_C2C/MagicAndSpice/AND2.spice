* NGSPICE file created from AND2.ext - technology: sky130A

.subckt AND2 A B Y VDD GND
X0 a_90_n200# B GND GND sky130_fd_pr__nfet_01v8 ad=0.25 pd=2.25 as=0.8 ps=4.8 w=2 l=0.5
X1 a_n100_1100# A a_90_n200# GND sky130_fd_pr__nfet_01v8 ad=0.8 pd=4.8 as=0.25 ps=2.25 w=2 l=0.5
X2 Y a_n100_1100# GND GND sky130_fd_pr__nfet_01v8 ad=0.4 pd=2.8 as=0.4 ps=2.8 w=1 l=0.5
X3 VDD B a_n100_1100# VDD sky130_fd_pr__pfet_01v8 ad=0.45 pd=2.45 as=0.9 ps=4.9 w=2 l=0.5
X4 a_n100_1100# A VDD VDD sky130_fd_pr__pfet_01v8 ad=0.9 pd=4.9 as=0.45 ps=2.45 w=2 l=0.5
X5 Y a_n100_1100# VDD VDD sky130_fd_pr__pfet_01v8 ad=0.804 pd=4.82 as=0.804 ps=4.82 w=2.01 l=0.5
.ends
