* NGSPICE file created from CDAC.ext - technology: sky130A

.subckt x5v_pfet_1_10 S G D B
X0 D G S B sky130_fd_pr__pfet_g5v0d10v5 ad=30 pd=26 as=30 ps=26 w=10 l=1
.ends

.subckt x5v_nfet_1_10 S G D B
X0 D G S B sky130_fd_pr__nfet_g5v0d10v5 ad=30 pd=26 as=30 ps=26 w=10 l=1
.ends

.subckt Tgate in out Cbar VDD VSS C
X5v_pfet_1_10_0 in Cbar out VDD x5v_pfet_1_10
X5v_nfet_1_10_0 out C in VSS x5v_nfet_1_10
.ends

.subckt SPDT in1 in2 out Cbar VDD VSS C
XTgate_0 in1 out Cbar VDD VSS C Tgate
XTgate_1 in2 out C VDD VSS Cbar Tgate
.ends

.subckt cap_m3_10_5 Top Bot
X0 Top Bot sky130_fd_pr__cap_mim_m3_1 l=5 w=10
.ends

.subckt cap_m3_20_10 Top Bot
X0 Top Bot sky130_fd_pr__cap_mim_m3_1 l=10 w=20
.ends

.subckt cap_m3_10_10 Top Bot
X0 Top Bot sky130_fd_pr__cap_mim_m3_1 l=10 w=10
.ends

.subckt cap_m3_5_5 Top Bot
X0 Top Bot sky130_fd_pr__cap_mim_m3_1 l=5 w=5
.ends

.subckt CDAC clkbar Vin b3 b2 b1 b0 clk Vout Vcm VDD VSS
XSPDT_4 VSS Vin SPDT_4/out clkbar VDD VSS clk SPDT
XSPDT_3 b0 Vin SPDT_3/out clkbar VDD VSS clk SPDT
Xcap_m3_10_5_0 SPDT_2/out Vout cap_m3_10_5
Xcap_m3_20_10_0 SPDT_0/out Vout cap_m3_20_10
Xcap_m3_10_10_0 SPDT_1/out Vout cap_m3_10_10
XTgate_0 Vout Vcm clkbar VDD VSS clk Tgate
Xcap_m3_5_5_0 SPDT_3/out Vout cap_m3_5_5
Xcap_m3_5_5_1 SPDT_4/out Vout cap_m3_5_5
XSPDT_0 b3 Vin SPDT_0/out clkbar VDD VSS clk SPDT
XSPDT_1 b2 Vin SPDT_1/out clkbar VDD VSS clk SPDT
XSPDT_2 b1 Vin SPDT_2/out clkbar VDD VSS clk SPDT
.ends
