* SPICE3 file created from CDAC.ext - technology: sky130A

X0 SPDT_4/out clkbar VSS VDD sky130_fd_pr__pfet_g5v0d10v5 ad=30 pd=26 as=30 ps=26 w=10 l=1
X1 VSS clk SPDT_4/out VSS sky130_fd_pr__nfet_g5v0d10v5 ad=30 pd=26 as=30 ps=26 w=10 l=1
X2 SPDT_4/out clk Vin VDD sky130_fd_pr__pfet_g5v0d10v5 ad=60 pd=52 as=150 ps=130 w=10 l=1
X3 Vin clkbar SPDT_4/out VSS sky130_fd_pr__nfet_g5v0d10v5 ad=150 pd=130 as=60 ps=52 w=10 l=1
X4 SPDT_3/out clkbar b0 VDD sky130_fd_pr__pfet_g5v0d10v5 ad=60 pd=52 as=30 ps=26 w=10 l=1
X5 b0 clk SPDT_3/out VSS sky130_fd_pr__nfet_g5v0d10v5 ad=30 pd=26 as=60 ps=52 w=10 l=1
X6 SPDT_3/out clk Vin VDD sky130_fd_pr__pfet_g5v0d10v5 ad=0 pd=0 as=0 ps=0 w=10 l=1
X7 Vin clkbar SPDT_3/out VSS sky130_fd_pr__nfet_g5v0d10v5 ad=0 pd=0 as=0 ps=0 w=10 l=1
X8 SPDT_2/out Vout sky130_fd_pr__cap_mim_m3_1 l=5 w=10
X9 SPDT_0/out Vout sky130_fd_pr__cap_mim_m3_1 l=10 w=20
X10 SPDT_1/out Vout sky130_fd_pr__cap_mim_m3_1 l=10 w=10
X11 Vcm clkbar Vout VDD sky130_fd_pr__pfet_g5v0d10v5 ad=30 pd=26 as=30 ps=26 w=10 l=1
X12 Vout clk Vcm VSS sky130_fd_pr__nfet_g5v0d10v5 ad=30 pd=26 as=30 ps=26 w=10 l=1
X13 SPDT_3/out Vout sky130_fd_pr__cap_mim_m3_1 l=5 w=5
X14 SPDT_4/out Vout sky130_fd_pr__cap_mim_m3_1 l=5 w=5
X15 SPDT_0/out clkbar b3 VDD sky130_fd_pr__pfet_g5v0d10v5 ad=60 pd=52 as=30 ps=26 w=10 l=1
X16 b3 clk SPDT_0/out VSS sky130_fd_pr__nfet_g5v0d10v5 ad=30 pd=26 as=60 ps=52 w=10 l=1
X17 SPDT_0/out clk Vin VDD sky130_fd_pr__pfet_g5v0d10v5 ad=0 pd=0 as=0 ps=0 w=10 l=1
X18 Vin clkbar SPDT_0/out VSS sky130_fd_pr__nfet_g5v0d10v5 ad=0 pd=0 as=0 ps=0 w=10 l=1
X19 SPDT_1/out clkbar b2 VDD sky130_fd_pr__pfet_g5v0d10v5 ad=60 pd=52 as=30 ps=26 w=10 l=1
X20 b2 clk SPDT_1/out VSS sky130_fd_pr__nfet_g5v0d10v5 ad=30 pd=26 as=60 ps=52 w=10 l=1
X21 SPDT_1/out clk Vin VDD sky130_fd_pr__pfet_g5v0d10v5 ad=0 pd=0 as=0 ps=0 w=10 l=1
X22 Vin clkbar SPDT_1/out VSS sky130_fd_pr__nfet_g5v0d10v5 ad=0 pd=0 as=0 ps=0 w=10 l=1
X23 SPDT_2/out clkbar b1 VDD sky130_fd_pr__pfet_g5v0d10v5 ad=60 pd=52 as=30 ps=26 w=10 l=1
X24 b1 clk SPDT_2/out VSS sky130_fd_pr__nfet_g5v0d10v5 ad=30 pd=26 as=60 ps=52 w=10 l=1
X25 SPDT_2/out clk Vin VDD sky130_fd_pr__pfet_g5v0d10v5 ad=0 pd=0 as=0 ps=0 w=10 l=1
X26 Vin clkbar SPDT_2/out VSS sky130_fd_pr__nfet_g5v0d10v5 ad=0 pd=0 as=0 ps=0 w=10 l=1
C0 b0 b1 2.89885f
C1 clkbar SPDT_2/out 2.6791f
C2 Vin SPDT_2/out 3.38984f
C3 VDD clkbar 3.32459f
C4 VDD Vin 3.4649f
C5 SPDT_0/out Vout 2.45141f
C6 clkbar b1 2.81771f
C7 clkbar Vout 18.49431f
C8 SPDT_4/out clkbar 2.94388f
C9 Vin Vout 5.69278f
C10 SPDT_4/out Vin 3.7635f
C11 clk b1 3.44632f
C12 Vout clk 5.9219f
C13 SPDT_1/out Vout 2.15466f
C14 b0 clkbar 4.17624f
C15 b0 Vin 2.88691f
C16 Vout SPDT_3/out 2.18178f
C17 b3 clk 2.67112f
C18 clk b2 2.91648f
C19 clkbar SPDT_0/out 2.68152f
C20 Vin SPDT_0/out 2.861f
C21 VDD Vout 9.74271f
C22 b0 clk 6.22194f
C23 clkbar Vin 6.0149f
C24 SPDT_0/out clk 2.61741f
C25 SPDT_4/out Vout 2.58648f
C26 clkbar clk 10.05477f
C27 Vin clk 7.87786f
C28 SPDT_1/out clkbar 2.60439f
C29 Vout b2 2.04112f
C30 SPDT_1/out Vin 3.24953f
C31 clkbar SPDT_3/out 2.91052f
C32 Vin SPDT_3/out 4.501f
C33 SPDT_2/out VSS 3.5589f
C34 b1 VSS 2.87611f
C35 SPDT_1/out VSS 3.30842f
C36 clkbar VSS 11.17746f
C37 Vin VSS 7.61357f
C38 SPDT_0/out VSS 4.12402f
C39 clk VSS 18.51077f
C40 VDD VSS 0.16161p
C41 Vout VSS 12.29942f
C42 SPDT_3/out VSS 3.8634f
C43 b0 VSS 3.99159f
C44 SPDT_4/out VSS 4.78275f
