* SPICE3 file created from strongarm.ext - technology: sky130A

X0 outn clk 5v_pfet_1_2_1/S 5v_pfet_1_2_1/S sky130_fd_pr__pfet_g5v0d10v5 ad=1 pd=4 as=1 ps=4 w=1 l=1
X1 clk clk 5v_pfet_1_2_1/S 5v_pfet_1_2_1/S sky130_fd_pr__pfet_g5v0d10v5 ad=1 pd=4 as=8 ps=28 w=1 l=1
X2 outp clk 5v_pfet_1_2_1/S 5v_pfet_1_2_1/S sky130_fd_pr__pfet_g5v0d10v5 ad=3 pd=10 as=0 ps=0 w=1 l=1
X3 5v_pfet_1_1_3/D clk 5v_pfet_1_2_1/S 5v_pfet_1_2_1/S sky130_fd_pr__pfet_g5v0d10v5 ad=1 pd=4 as=0 ps=0 w=1 l=1
X4 outn outp 5v_pfet_1_2_1/S 5v_pfet_1_2_1/S sky130_fd_pr__pfet_g5v0d10v5 ad=2 pd=6 as=2 ps=6 w=2 l=1
X5 outp outn 5v_pfet_1_2_1/S 5v_pfet_1_2_1/S sky130_fd_pr__pfet_g5v0d10v5 ad=0 pd=0 as=0 ps=0 w=2 l=1
X6 outn outp clk VSS sky130_fd_pr__nfet_g5v0d10v5 ad=1 pd=4 as=1 ps=4 w=1 l=1
X7 5v_nfet_1_1_3/S clk VSS VSS sky130_fd_pr__nfet_g5v0d10v5 ad=3 pd=12 as=1 ps=4 w=1 l=1
X8 clk Vinp 5v_nfet_1_1_3/S VSS sky130_fd_pr__nfet_g5v0d10v5 ad=2 pd=8 as=0 ps=0 w=1 l=1
X9 5v_pfet_1_1_3/D Vinn 5v_nfet_1_1_3/S VSS sky130_fd_pr__nfet_g5v0d10v5 ad=2 pd=8 as=0 ps=0 w=1 l=1
X10 outp outn 5v_pfet_1_1_3/D VSS sky130_fd_pr__nfet_g5v0d10v5 ad=1 pd=4 as=0 ps=0 w=1 l=1
C0 outn outp 3.23849f
C1 5v_pfet_1_2_1/S clk 4.34485f
C2 clk outp 2.50175f
C3 outn 5v_pfet_1_2_1/S 2.25245f
C4 5v_pfet_1_2_1/S outp 2.56968f
C5 5v_pfet_1_2_1/S VSS 18.39402f
C6 clk VSS 2.54803f
