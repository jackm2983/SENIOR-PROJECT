* SPICE3 file created from strongarm.ext - technology: sky130A

.subckt x5v_pfet_1_1 S B G D
X0 D G S B sky130_fd_pr__pfet_g5v0d10v5 ad=1 pd=4 as=1 ps=4 w=1 l=1
.ends

.subckt x5v_pfet_1_2 B D G S
X0 D G S B sky130_fd_pr__pfet_g5v0d10v5 ad=2 pd=6 as=2 ps=6 w=2 l=1
.ends

.subckt x5v_nfet_1_1 S B G D
X0 D G S B sky130_fd_pr__nfet_g5v0d10v5 ad=1 pd=4 as=1 ps=4 w=1 l=1
.ends

.subckt strongarm Vinp Vinn clk outp outn VDD VSS
X5v_pfet_1_1_1 VDD VDD clk outn x5v_pfet_1_1
X5v_pfet_1_1_0 VDD VDD clk clk x5v_pfet_1_1
X5v_pfet_1_1_2 VDD VDD clk outp x5v_pfet_1_1
X5v_pfet_1_1_3 VDD VDD clk 5v_pfet_1_1_3/D x5v_pfet_1_1
X5v_pfet_1_2_0 VDD outn outp VDD x5v_pfet_1_2
X5v_pfet_1_2_1 VDD outp outn VDD x5v_pfet_1_2
X5v_nfet_1_1_0 clk VSS outp outn x5v_nfet_1_1
X5v_nfet_1_1_2 VSS VSS clk 5v_nfet_1_1_3/S x5v_nfet_1_1
X5v_nfet_1_1_1 5v_nfet_1_1_3/S VSS Vinp clk x5v_nfet_1_1
X5v_nfet_1_1_3 5v_nfet_1_1_3/S VSS Vinn 5v_pfet_1_1_3/D x5v_nfet_1_1
X5v_nfet_1_1_4 5v_pfet_1_1_3/D VSS outn outp x5v_nfet_1_1
.ends
