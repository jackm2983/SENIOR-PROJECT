* SPICE3 file created from AND5v.ext - technology: sky130A

X0 Y A 5v_nfet_1_2_1/D VSS sky130_fd_pr__nfet_g5v0d10v5 ad=2 pd=6 as=2 ps=6 w=2 l=1
X1 5v_nfet_1_2_1/D B VSS VSS sky130_fd_pr__nfet_g5v0d10v5 ad=4 pd=12 as=2 ps=6 w=2 l=1
X2 Y A VDD VDD sky130_fd_pr__pfet_g5v0d10v5 ad=2 pd=6 as=2 ps=6 w=2 l=1
X3 Y B VDD VDD sky130_fd_pr__pfet_g5v0d10v5 ad=4 pd=12 as=4 ps=12 w=2 l=1
C0 VDD VSS 6.4079f
