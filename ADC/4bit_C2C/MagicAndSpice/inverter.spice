* NGSPICE file created from inverter.ext - technology: sky130A

.subckt inverter Y VP VN A
X0 Y A VN VN sky130_fd_pr__nfet_01v8 ad=0.4 pd=2.8 as=0.4 ps=2.8 w=1 l=0.5
X1 Y A VP VP sky130_fd_pr__pfet_01v8 ad=0.804 pd=4.82 as=0.804 ps=4.82 w=2.01 l=0.5
.ends
