* NGSPICE file created from shift5to1v8.ext - technology: sky130A

.subckt x5v_pfet_1_2 B D G S
X0 D G S B sky130_fd_pr__pfet_g5v0d10v5 ad=2 pd=6 as=2 ps=6 w=2 l=1
.ends

.subckt x5v_nfet_1_1 S B G D
X0 D G S B sky130_fd_pr__nfet_g5v0d10v5 ad=1 pd=4 as=1 ps=4 w=1 l=1
.ends

.subckt shift5to1v8 A Y VP VN
X5v_pfet_1_2_0 VP 5v_pfet_1_2_1/G A VP x5v_pfet_1_2
X5v_pfet_1_2_1 VP Y 5v_pfet_1_2_1/G VP x5v_pfet_1_2
X5v_nfet_1_1_0 VN VN A 5v_pfet_1_2_1/G x5v_nfet_1_1
X5v_nfet_1_1_1 VN VN 5v_pfet_1_2_1/G Y x5v_nfet_1_1
.ends
