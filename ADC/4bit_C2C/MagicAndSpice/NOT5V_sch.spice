** sch_path: /home/ee431/workspace/6SAR_CDAC/NOT5V.sch
.subckt NOT5V X Y VSS VDD
*.PININFO X:I Y:O VSS:B VDD:B
XM1 Y X VSS VSS sky130_fd_pr__nfet_g5v0d10v5 L=1 W=1 nf=1 m=1
XM2 Y X VDD VDD sky130_fd_pr__pfet_g5v0d10v5 L=1 W=2 nf=1 m=1
.ends
.end
