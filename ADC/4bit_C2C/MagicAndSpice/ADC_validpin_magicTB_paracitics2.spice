.lib /usr/local/share/pdk/sky130A/libs.tech/combined/sky130.lib.spice tt
.include /home/ee431/workspace/6SAR_CDAC/postlayout.spice

V2 CLK VSS PULSE(0 1.8 0 10n 10n 312.5u 625u)
V3 CLK_comp VSS PULSE(0 1.8 156.25u 10n 10n 312.5u 625u)
V1 Vin VSS PWL(0 0 625u 0 80.625m 5)
V4 VDD_5V VSS 5
V7 VDD1v8 VSS 1.8
V5 VSS 0 0
V10 RST_N VSS PULSE(0 1.8 625u 10n 10n 1e9 2e9)

.tran 100u 80.625m 0 100u
.options method=gear reltol=1e-4

.control
run
plot v(Vin) v(ADC_OUT0)+5 v(ADC_OUT1)+8 v(ADC_OUT2)+11 v(ADC_OUT3)+14 v(VALID)+17
wrdata adc_tran_cap.txt v(Vin) v(ADC_OUT0) v(ADC_OUT1) v(ADC_OUT2) v(ADC_OUT3) v(VALID)
.endc

.end
