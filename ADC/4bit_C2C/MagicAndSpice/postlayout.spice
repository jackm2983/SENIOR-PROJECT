* NGSPICE file created from ADC_validpin.ext - technology: sky130A

X0 CDAC_0/Vcm VSS VSS sky130_fd_pr__res_xhigh_po w=2 l=10.01
X1 shift1v8to5_0/5v_pfet_1_2_2/D shift1v8to5_0/A VSS VSS sky130_fd_pr__nfet_g5v0d10v5 ad=18 pd=18 as=16.25 ps=18.375 w=6 l=1
X2 CDAC_0/b1 shift1v8to5_0/5v_pfet_1_2_0/D VSS VSS sky130_fd_pr__nfet_g5v0d10v5 ad=18 pd=16.5 as=16.25 ps=18.375 w=6 l=1
X3 shift1v8to5_0/5v_pfet_1_2_0/D shift1v8to5_0/A VDD1v8 VDD1v8 sky130_fd_pr__pfet_g5v0d10v5 ad=2 pd=6 as=2 ps=6 w=2 l=1
X4 CDAC_0/b1 shift1v8to5_0/5v_pfet_1_2_2/D VDD_5V VDD_5V sky130_fd_pr__pfet_g5v0d10v5 ad=5.333333 pd=5.333333 as=2 ps=6.190476 w=2 l=1
X5 shift1v8to5_0/5v_pfet_1_2_2/D CDAC_0/b1 VDD_5V VDD_5V sky130_fd_pr__pfet_g5v0d10v5 ad=2 pd=6 as=2 ps=6.190476 w=2 l=1
X6 shift1v8to5_0/5v_pfet_1_2_0/D shift1v8to5_0/A VSS VSS sky130_fd_pr__nfet_g5v0d10v5 ad=1 pd=4 as=2.708333 ps=3.0625 w=1 l=1
X7 SRLatch5V_0/NQ SRLatch5V_0/Q SRLatch5V_0/NAND5v_0/5v_nfet_1_2_1/D VSS sky130_fd_pr__nfet_g5v0d10v5 ad=2 pd=6 as=2 ps=6 w=2 l=1
X8 SRLatch5V_0/NAND5v_0/5v_nfet_1_2_1/D SRLatch5V_0/R VSS VSS sky130_fd_pr__nfet_g5v0d10v5 ad=2 pd=6 as=5.416667 ps=6.125 w=2 l=1
X9 SRLatch5V_0/NQ SRLatch5V_0/Q VDD_5V VDD_5V sky130_fd_pr__pfet_g5v0d10v5 ad=2 pd=6 as=2 ps=6.190476 w=2 l=1
X10 SRLatch5V_0/NQ SRLatch5V_0/R VDD_5V VDD_5V sky130_fd_pr__pfet_g5v0d10v5 ad=2 pd=6 as=2 ps=6.190476 w=2 l=1
X11 SRLatch5V_0/Q SRLatch5V_0/S SRLatch5V_0/NAND5v_1/5v_nfet_1_2_1/D VSS sky130_fd_pr__nfet_g5v0d10v5 ad=2 pd=6 as=2 ps=6 w=2 l=1
X12 SRLatch5V_0/NAND5v_1/5v_nfet_1_2_1/D SRLatch5V_0/NQ VSS VSS sky130_fd_pr__nfet_g5v0d10v5 ad=2 pd=6 as=5.416667 ps=6.125 w=2 l=1
X13 SRLatch5V_0/Q SRLatch5V_0/S VDD_5V VDD_5V sky130_fd_pr__pfet_g5v0d10v5 ad=2 pd=6 as=2 ps=6.190476 w=2 l=1
X14 SRLatch5V_0/Q SRLatch5V_0/NQ VDD_5V VDD_5V sky130_fd_pr__pfet_g5v0d10v5 ad=2 pd=6 as=2 ps=6.190476 w=2 l=1
X15 CDAC_0/Vcm VDD_5V VSS sky130_fd_pr__res_xhigh_po w=2 l=10.01
X16 shift1v8to5_1/5v_pfet_1_2_2/D shift1v8to5_1/A VSS VSS sky130_fd_pr__nfet_g5v0d10v5 ad=18 pd=18 as=16.25 ps=18.375 w=6 l=1
X17 CDAC_0/b0 shift1v8to5_1/5v_pfet_1_2_0/D VSS VSS sky130_fd_pr__nfet_g5v0d10v5 ad=18 pd=16.5 as=16.25 ps=18.375 w=6 l=1
X18 shift1v8to5_1/5v_pfet_1_2_0/D shift1v8to5_1/A VDD1v8 VDD1v8 sky130_fd_pr__pfet_g5v0d10v5 ad=2 pd=6 as=2 ps=6 w=2 l=1
X19 CDAC_0/b0 shift1v8to5_1/5v_pfet_1_2_2/D VDD_5V VDD_5V sky130_fd_pr__pfet_g5v0d10v5 ad=5.333333 pd=5.333333 as=2 ps=6.190476 w=2 l=1
X20 shift1v8to5_1/5v_pfet_1_2_2/D CDAC_0/b0 VDD_5V VDD_5V sky130_fd_pr__pfet_g5v0d10v5 ad=2 pd=6 as=2 ps=6.190476 w=2 l=1
X21 shift1v8to5_1/5v_pfet_1_2_0/D shift1v8to5_1/A VSS VSS sky130_fd_pr__nfet_g5v0d10v5 ad=1 pd=4 as=2.708333 ps=3.0625 w=1 l=1
X22 shift1v8to5_2/5v_pfet_1_2_2/D shift1v8to5_2/A VSS VSS sky130_fd_pr__nfet_g5v0d10v5 ad=18 pd=18 as=16.25 ps=18.375 w=6 l=1
X23 CDAC_0/b3 shift1v8to5_2/5v_pfet_1_2_0/D VSS VSS sky130_fd_pr__nfet_g5v0d10v5 ad=18 pd=16.5 as=16.25 ps=18.375 w=6 l=1
X24 shift1v8to5_2/5v_pfet_1_2_0/D shift1v8to5_2/A VDD1v8 VDD1v8 sky130_fd_pr__pfet_g5v0d10v5 ad=2 pd=6 as=2 ps=6 w=2 l=1
X25 CDAC_0/b3 shift1v8to5_2/5v_pfet_1_2_2/D VDD_5V VDD_5V sky130_fd_pr__pfet_g5v0d10v5 ad=5.333333 pd=5.333333 as=2 ps=6.190476 w=2 l=1
X26 shift1v8to5_2/5v_pfet_1_2_2/D CDAC_0/b3 VDD_5V VDD_5V sky130_fd_pr__pfet_g5v0d10v5 ad=2 pd=6 as=2 ps=6.190476 w=2 l=1
X27 shift1v8to5_2/5v_pfet_1_2_0/D shift1v8to5_2/A VSS VSS sky130_fd_pr__nfet_g5v0d10v5 ad=1 pd=4 as=2.708333 ps=3.0625 w=1 l=1
X28 shift1v8to5_3/5v_pfet_1_2_2/D shift1v8to5_3/A VSS VSS sky130_fd_pr__nfet_g5v0d10v5 ad=18 pd=18 as=16.25 ps=18.375 w=6 l=1
X29 CDAC_0/b2 shift1v8to5_3/5v_pfet_1_2_0/D VSS VSS sky130_fd_pr__nfet_g5v0d10v5 ad=18 pd=16.5 as=16.25 ps=18.375 w=6 l=1
X30 shift1v8to5_3/5v_pfet_1_2_0/D shift1v8to5_3/A VDD1v8 VDD1v8 sky130_fd_pr__pfet_g5v0d10v5 ad=2 pd=6 as=2 ps=6 w=2 l=1
X31 CDAC_0/b2 shift1v8to5_3/5v_pfet_1_2_2/D VDD_5V VDD_5V sky130_fd_pr__pfet_g5v0d10v5 ad=5.333333 pd=5.333333 as=2 ps=6.190476 w=2 l=1
X32 shift1v8to5_3/5v_pfet_1_2_2/D CDAC_0/b2 VDD_5V VDD_5V sky130_fd_pr__pfet_g5v0d10v5 ad=2 pd=6 as=2 ps=6.190476 w=2 l=1
X33 shift1v8to5_3/5v_pfet_1_2_0/D shift1v8to5_3/A VSS VSS sky130_fd_pr__nfet_g5v0d10v5 ad=1 pd=4 as=2.708333 ps=3.0625 w=1 l=1
X34 SAR_validpin_0/OR2_0/a_100_310# SAR_validpin_0/OR2_0/B VDD1v8 VDD1v8 sky130_fd_pr__pfet_01v8 ad=0.5 pd=4.25 as=0.905774 ps=5.224219 w=4 l=0.5
X35 VSS SAR_validpin_0/OR2_0/B SAR_validpin_0/OR2_0/a_n80_n540# VSS sky130_fd_pr__nfet_01v8 ad=0.310542 pd=1.943976 as=0.4 ps=2.8 w=1 l=0.5
X36 SAR_validpin_0/OR2_0/a_n80_n540# SAR_validpin_0/OR2_0/A VSS VSS sky130_fd_pr__nfet_01v8 ad=0.4 pd=2.8 as=0.310542 ps=1.943976 w=1 l=0.5
X37 SAR_validpin_0/OR2_0/a_n80_n540# SAR_validpin_0/OR2_0/A SAR_validpin_0/OR2_0/a_100_310# VDD1v8 sky130_fd_pr__pfet_01v8 ad=1.4 pd=8.7 as=0.5 ps=4.25 w=4 l=0.5
X38 shift1v8to5_0/A SAR_validpin_0/OR2_0/a_n80_n540# VSS VSS sky130_fd_pr__nfet_01v8 ad=0.4 pd=2.8 as=0.310542 ps=1.943976 w=1 l=0.5
X39 shift1v8to5_0/A SAR_validpin_0/OR2_0/a_n80_n540# VDD1v8 VDD1v8 sky130_fd_pr__pfet_01v8 ad=0.8 pd=4.8 as=0.452887 ps=2.61211 w=2 l=0.5
X40 SAR_validpin_0/OR2_1/a_100_310# SAR_validpin_0/OR2_1/B VDD1v8 VDD1v8 sky130_fd_pr__pfet_01v8 ad=0.5 pd=4.25 as=0.905774 ps=5.224219 w=4 l=0.5
X41 VSS SAR_validpin_0/OR2_1/B SAR_validpin_0/OR2_1/a_n80_n540# VSS sky130_fd_pr__nfet_01v8 ad=0.310542 pd=1.943976 as=0.4 ps=2.8 w=1 l=0.5
X42 SAR_validpin_0/OR2_1/a_n80_n540# SAR_validpin_0/OR2_1/A VSS VSS sky130_fd_pr__nfet_01v8 ad=0.4 pd=2.8 as=0.310542 ps=1.943976 w=1 l=0.5
X43 SAR_validpin_0/OR2_1/a_n80_n540# SAR_validpin_0/OR2_1/A SAR_validpin_0/OR2_1/a_100_310# VDD1v8 sky130_fd_pr__pfet_01v8 ad=1.4 pd=8.7 as=0.5 ps=4.25 w=4 l=0.5
X44 shift1v8to5_3/A SAR_validpin_0/OR2_1/a_n80_n540# VSS VSS sky130_fd_pr__nfet_01v8 ad=0.4 pd=2.8 as=0.310542 ps=1.943976 w=1 l=0.5
X45 shift1v8to5_3/A SAR_validpin_0/OR2_1/a_n80_n540# VDD1v8 VDD1v8 sky130_fd_pr__pfet_01v8 ad=0.8 pd=4.8 as=0.452887 ps=2.61211 w=2 l=0.5
X46 SAR_validpin_0/DFFRR_1/D SAR_validpin_0/2_1_MUX_0/a_n1230_n310# SAR_validpin_0/OR2_0/A VSS sky130_fd_pr__nfet_01v8 ad=1.35 pd=6.9 as=1.3125 ps=7.275 w=3 l=0.5
X47 SAR_validpin_0/DFFRR_1/D SAR_validpin_0/OR2_0/B SAR_validpin_0/OR2_0/A VDD1v8 sky130_fd_pr__pfet_01v8 ad=1.35 pd=6.9 as=1.29 ps=7.02 w=3 l=0.5
X48 SAR_validpin_0/2_1_MUX_0/a_n1230_n310# SAR_validpin_0/OR2_0/B VDD1v8 VDD1v8 sky130_fd_pr__pfet_01v8 ad=0.9 pd=4.9 as=0.452887 ps=2.61211 w=2 l=0.5
X49 SAR_validpin_0/2_1_MUX_0/a_n1230_n310# SAR_validpin_0/OR2_0/B VSS VSS sky130_fd_pr__nfet_01v8 ad=0.45 pd=2.9 as=0.310542 ps=1.943976 w=1 l=0.5
X50 shift5to1v8_0/Y SAR_validpin_0/2_1_MUX_0/a_n1230_n310# SAR_validpin_0/DFFRR_1/D VDD1v8 sky130_fd_pr__pfet_01v8 ad=1.35 pd=6.9 as=1.35 ps=6.9 w=3 l=0.5
X51 shift5to1v8_0/Y SAR_validpin_0/OR2_0/B SAR_validpin_0/DFFRR_1/D VSS sky130_fd_pr__nfet_01v8 ad=1.35 pd=6.9 as=1.35 ps=6.9 w=3 l=0.5
X52 SAR_validpin_0/OR2_2/a_100_310# SAR_validpin_0/OR2_2/B VDD1v8 VDD1v8 sky130_fd_pr__pfet_01v8 ad=0.5 pd=4.25 as=0.905774 ps=5.224219 w=4 l=0.5
X53 VSS SAR_validpin_0/OR2_2/B SAR_validpin_0/OR2_2/a_n80_n540# VSS sky130_fd_pr__nfet_01v8 ad=0.310542 pd=1.943976 as=0.4 ps=2.8 w=1 l=0.5
X54 SAR_validpin_0/OR2_2/a_n80_n540# SAR_validpin_0/OR2_2/A VSS VSS sky130_fd_pr__nfet_01v8 ad=0.4 pd=2.8 as=0.310542 ps=1.943976 w=1 l=0.5
X55 SAR_validpin_0/OR2_2/a_n80_n540# SAR_validpin_0/OR2_2/A SAR_validpin_0/OR2_2/a_100_310# VDD1v8 sky130_fd_pr__pfet_01v8 ad=1.4 pd=8.7 as=0.5 ps=4.25 w=4 l=0.5
X56 shift1v8to5_2/A SAR_validpin_0/OR2_2/a_n80_n540# VSS VSS sky130_fd_pr__nfet_01v8 ad=0.4 pd=2.8 as=0.310542 ps=1.943976 w=1 l=0.5
X57 shift1v8to5_2/A SAR_validpin_0/OR2_2/a_n80_n540# VDD1v8 VDD1v8 sky130_fd_pr__pfet_01v8 ad=0.8 pd=4.8 as=0.452887 ps=2.61211 w=2 l=0.5
X58 SAR_validpin_0/DFFRR_0/D SAR_validpin_0/2_1_MUX_1/a_n1230_n310# SAR_validpin_0/OR2_1/A VSS sky130_fd_pr__nfet_01v8 ad=1.35 pd=6.9 as=1.3125 ps=7.275 w=3 l=0.5
X59 SAR_validpin_0/DFFRR_0/D SAR_validpin_0/OR2_1/B SAR_validpin_0/OR2_1/A VDD1v8 sky130_fd_pr__pfet_01v8 ad=1.35 pd=6.9 as=1.29 ps=7.02 w=3 l=0.5
X60 SAR_validpin_0/2_1_MUX_1/a_n1230_n310# SAR_validpin_0/OR2_1/B VDD1v8 VDD1v8 sky130_fd_pr__pfet_01v8 ad=0.9 pd=4.9 as=0.452887 ps=2.61211 w=2 l=0.5
X61 SAR_validpin_0/2_1_MUX_1/a_n1230_n310# SAR_validpin_0/OR2_1/B VSS VSS sky130_fd_pr__nfet_01v8 ad=0.45 pd=2.9 as=0.310542 ps=1.943976 w=1 l=0.5
X62 shift5to1v8_0/Y SAR_validpin_0/2_1_MUX_1/a_n1230_n310# SAR_validpin_0/DFFRR_0/D VDD1v8 sky130_fd_pr__pfet_01v8 ad=1.35 pd=6.9 as=1.35 ps=6.9 w=3 l=0.5
X63 shift5to1v8_0/Y SAR_validpin_0/OR2_1/B SAR_validpin_0/DFFRR_0/D VSS sky130_fd_pr__nfet_01v8 ad=1.35 pd=6.9 as=1.35 ps=6.9 w=3 l=0.5
X64 SAR_validpin_0/DFFR_7/D SAR_validpin_0/2_1_MUX_2/a_n1230_n310# SAR_validpin_0/OR2_2/A VSS sky130_fd_pr__nfet_01v8 ad=1.35 pd=6.9 as=1.3125 ps=7.275 w=3 l=0.5
X65 SAR_validpin_0/DFFR_7/D SAR_validpin_0/OR2_2/B SAR_validpin_0/OR2_2/A VDD1v8 sky130_fd_pr__pfet_01v8 ad=1.35 pd=6.9 as=1.29 ps=7.02 w=3 l=0.5
X66 SAR_validpin_0/2_1_MUX_2/a_n1230_n310# SAR_validpin_0/OR2_2/B VDD1v8 VDD1v8 sky130_fd_pr__pfet_01v8 ad=0.9 pd=4.9 as=0.452887 ps=2.61211 w=2 l=0.5
X67 SAR_validpin_0/2_1_MUX_2/a_n1230_n310# SAR_validpin_0/OR2_2/B VSS VSS sky130_fd_pr__nfet_01v8 ad=0.45 pd=2.9 as=0.310542 ps=1.943976 w=1 l=0.5
X68 shift5to1v8_0/Y SAR_validpin_0/2_1_MUX_2/a_n1230_n310# SAR_validpin_0/DFFR_7/D VDD1v8 sky130_fd_pr__pfet_01v8 ad=1.35 pd=6.9 as=1.35 ps=6.9 w=3 l=0.5
X69 shift5to1v8_0/Y SAR_validpin_0/OR2_2/B SAR_validpin_0/DFFR_7/D VSS sky130_fd_pr__nfet_01v8 ad=1.35 pd=6.9 as=1.35 ps=6.9 w=3 l=0.5
X70 SAR_validpin_0/DFFR_0/a_2090_n400# SAR_validpin_0/DFFR_0/a_n50_n400# SAR_validpin_0/DFFR_0/a_450_n400# VDD1v8 sky130_fd_pr__pfet_01v8 ad=1.38 pd=7.08 as=1.2 ps=6.96 w=3 l=0.5
X71 VDD1v8 SAR_validpin_0/DFFR_0/a_2090_n400# SAR_validpin_0/DFFR_0/a_2600_n430# VDD1v8 sky130_fd_pr__pfet_01v8 ad=0.452887 pd=2.61211 as=0.8 ps=4.8 w=2 l=0.5
X72 VSS SARclkgen_0/PHIB SAR_validpin_0/DFFR_0/a_n420_n400# VSS sky130_fd_pr__nfet_01v8 ad=0.310542 pd=1.943976 as=0.4 ps=2.8 w=1 l=0.5
X73 SAR_validpin_0/DFFR_0/a_2550_n400# SAR_validpin_0/DFFR_0/a_n50_n400# SAR_validpin_0/DFFR_0/a_2090_n400# VSS sky130_fd_pr__nfet_01v8 ad=0.125 pd=1.25 as=0.475 ps=2.45 w=1 l=0.5
X74 VSS SAR_validpin_0/DFFR_0/a_2600_n430# SAR_validpin_0/DFFR_0/a_2550_n400# VSS sky130_fd_pr__nfet_01v8 ad=0.310542 pd=1.943976 as=0.125 ps=1.25 w=1 l=0.5
X75 SAR_validpin_0/DFFR_0/a_1460_n400# SAR_validpin_0/DFFR_0/a_450_n400# SAR_validpin_0/DFFR_0/a_1310_n400# VSS sky130_fd_pr__nfet_01v8 ad=0.375 pd=3.25 as=0.375 ps=3.25 w=3 l=0.5
X76 SAR_validpin_0/DFFR_0/a_350_n430# SAR_validpin_0/DFFR_0/a_n420_n400# SAR_validpin_0/DFFR_0/a_1460_n400# VSS sky130_fd_pr__nfet_01v8 ad=1.2 pd=6.8 as=0.375 ps=3.25 w=3 l=0.5
X77 VSS RST_N SAR_validpin_0/DFFR_0/a_3210_n400# VSS sky130_fd_pr__nfet_01v8 ad=0.621084 pd=3.887952 as=0.25 ps=2.25 w=2 l=0.5
X78 SAR_validpin_0/DFFR_0/a_90_n400# SARclkgen_0/PHIB SAR_validpin_0/DFFR_0/a_350_n430# VSS sky130_fd_pr__nfet_01v8 ad=1.425 pd=7.35 as=1.2 ps=6.8 w=3 l=0.5
X79 SAR_validpin_0/DFFR_0/a_n50_n400# SARclkgen_0/PHIA VDD1v8 VDD1v8 sky130_fd_pr__pfet_01v8 ad=0.8 pd=4.8 as=0.452887 ps=2.61211 w=2 l=0.5
X80 SAR_validpin_0/DFFR_0/a_n50_n400# SARclkgen_0/PHIA VSS VSS sky130_fd_pr__nfet_01v8 ad=0.4 pd=2.8 as=0.310542 ps=1.943976 w=1 l=0.5
X81 SAR_validpin_0/DFFR_0/a_2550_720# SARclkgen_0/PHIA SAR_validpin_0/DFFR_0/a_2090_n400# VDD1v8 sky130_fd_pr__pfet_01v8 ad=0.25 pd=2.25 as=0.92 ps=4.72 w=2 l=0.5
X82 SAR_validpin_0/DFFR_0/a_350_n430# SARclkgen_0/PHIB SAR_validpin_0/DFFR_0/a_1130_520# VDD1v8 sky130_fd_pr__pfet_01v8 ad=1.608572 pd=8.971429 as=1.066667 ps=5.866667 w=4 l=0.5
X83 SAR_validpin_0/DFFR_0/a_1130_520# SAR_validpin_0/DFFR_0/a_450_n400# VDD1v8 VDD1v8 sky130_fd_pr__pfet_01v8 ad=1.066667 pd=5.866667 as=0.905774 ps=5.224219 w=4 l=0.5
X84 SAR_validpin_0/OR2_1/B SAR_validpin_0/DFFR_0/a_2600_n430# VSS VSS sky130_fd_pr__nfet_01v8 ad=0.4 pd=2.8 as=0.310542 ps=1.943976 w=1 l=0.5
X85 SAR_validpin_0/OR2_1/B SAR_validpin_0/DFFR_0/a_2600_n430# VDD1v8 VDD1v8 sky130_fd_pr__pfet_01v8 ad=0.8 pd=4.8 as=0.452887 ps=2.61211 w=2 l=0.5
X86 SAR_validpin_0/DFFR_0/a_90_n400# SAR_validpin_0/DFFR_0/a_n420_n400# SAR_validpin_0/DFFR_0/a_350_n430# VDD1v8 sky130_fd_pr__pfet_01v8 ad=1.38 pd=7.08 as=1.206429 ps=6.728571 w=3 l=0.5
X87 SAR_validpin_0/DFFR_0/a_2600_n430# RST_N VDD1v8 VDD1v8 sky130_fd_pr__pfet_01v8 ad=0.8 pd=4.8 as=0.452887 ps=2.61211 w=2 l=0.5
X88 SAR_validpin_0/DFFR_0/a_450_n400# SAR_validpin_0/DFFR_0/a_350_n430# VDD1v8 VDD1v8 sky130_fd_pr__pfet_01v8 ad=0.8 pd=4.64 as=0.452887 ps=2.61211 w=2 l=0.5
X89 VDD1v8 RST_N SAR_validpin_0/DFFR_0/a_1130_520# VDD1v8 sky130_fd_pr__pfet_01v8 ad=0.905774 pd=5.224219 as=1.066667 ps=5.866667 w=4 l=0.5
X90 VSS SAR_validpin_0/OR2_2/B SAR_validpin_0/DFFR_0/a_90_n400# VSS sky130_fd_pr__nfet_01v8 ad=0.310542 pd=1.943976 as=0.475 ps=2.45 w=1 l=0.5
X91 SAR_validpin_0/DFFR_0/a_2090_n400# SARclkgen_0/PHIA SAR_validpin_0/DFFR_0/a_450_n400# VSS sky130_fd_pr__nfet_01v8 ad=1.425 pd=7.35 as=1.2 ps=7.2 w=3 l=0.5
X92 VDD1v8 SAR_validpin_0/OR2_2/B SAR_validpin_0/DFFR_0/a_90_n400# VDD1v8 sky130_fd_pr__pfet_01v8 ad=0.452887 pd=2.61211 as=0.92 ps=4.72 w=2 l=0.5
X93 SAR_validpin_0/DFFR_0/a_450_n400# SAR_validpin_0/DFFR_0/a_350_n430# VSS VSS sky130_fd_pr__nfet_01v8 ad=0.4 pd=2.4 as=0.310542 ps=1.943976 w=1 l=0.5
X94 SAR_validpin_0/DFFR_0/a_1310_n400# RST_N VSS VSS sky130_fd_pr__nfet_01v8 ad=0.375 pd=3.25 as=0.931626 ps=5.831927 w=3 l=0.5
X95 VDD1v8 SARclkgen_0/PHIB SAR_validpin_0/DFFR_0/a_n420_n400# VDD1v8 sky130_fd_pr__pfet_01v8 ad=0.452887 pd=2.61211 as=0.8 ps=4.8 w=2 l=0.5
X96 SAR_validpin_0/DFFR_0/a_3210_n400# SAR_validpin_0/DFFR_0/a_2090_n400# SAR_validpin_0/DFFR_0/a_2600_n430# VSS sky130_fd_pr__nfet_01v8 ad=0.25 pd=2.25 as=0.8 ps=4.8 w=2 l=0.5
X97 VDD1v8 SAR_validpin_0/DFFR_0/a_2600_n430# SAR_validpin_0/DFFR_0/a_2550_720# VDD1v8 sky130_fd_pr__pfet_01v8 ad=0.452887 pd=2.61211 as=0.25 ps=2.25 w=2 l=0.5
X98 SAR_validpin_0/DFFRR_0/a_n420_720# SAR_validpin_0/DFFRR_0/D VDD1v8 VDD1v8 sky130_fd_pr__pfet_01v8 ad=0.885714 pd=4.742857 as=0.452887 ps=2.61211 w=2 l=0.5
X99 SAR_validpin_0/DFFRR_0/a_2090_n400# SAR_validpin_0/DFFRR_0/a_n560_n400# SAR_validpin_0/DFFRR_0/a_450_n400# VDD1v8 sky130_fd_pr__pfet_01v8 ad=1.38 pd=7.08 as=1.2 ps=6.96 w=3 l=0.5
X100 SAR_validpin_0/DFFRR_0/a_n420_720# SAR_validpin_0/DFFRR_0/D SAR_validpin_0/DFFRR_0/a_n240_n400# VSS sky130_fd_pr__nfet_01v8 ad=0.92 pd=4.72 as=0.25 ps=2.25 w=2 l=0.5
X101 VDD1v8 SAR_validpin_0/DFFRR_0/a_2090_n400# SAR_validpin_0/DFFRR_0/a_2600_n430# VDD1v8 sky130_fd_pr__pfet_01v8 ad=0.452887 pd=2.61211 as=0.8 ps=4.8 w=2 l=0.5
X102 SAR_validpin_0/DFFRR_0/a_n240_n400# SAR_validpin_0/DFFRR_0/a_n340_n430# VSS VSS sky130_fd_pr__nfet_01v8 ad=0.25 pd=2.25 as=0.621084 ps=3.887952 w=2 l=0.5
X103 SAR_validpin_0/DFFRR_0/a_2550_n400# SAR_validpin_0/DFFRR_0/a_n560_n400# SAR_validpin_0/DFFRR_0/a_2090_n400# VSS sky130_fd_pr__nfet_01v8 ad=0.125 pd=1.25 as=0.475 ps=2.45 w=1 l=0.5
X104 VSS SAR_validpin_0/DFFRR_0/a_2600_n430# SAR_validpin_0/DFFRR_0/a_2550_n400# VSS sky130_fd_pr__nfet_01v8 ad=0.310542 pd=1.943976 as=0.125 ps=1.25 w=1 l=0.5
X105 SAR_validpin_0/DFFRR_0/a_1460_n400# SAR_validpin_0/DFFRR_0/a_450_n400# SAR_validpin_0/DFFRR_0/a_1310_n400# VSS sky130_fd_pr__nfet_01v8 ad=0.375 pd=3.25 as=0.375 ps=3.25 w=3 l=0.5
X106 SAR_validpin_0/DFFRR_0/a_350_n430# SAR_validpin_0/DFFRR_0/a_n930_n400# SAR_validpin_0/DFFRR_0/a_1460_n400# VSS sky130_fd_pr__nfet_01v8 ad=1.2 pd=6.8 as=0.375 ps=3.25 w=3 l=0.5
X107 VDD1v8 SARclkgen_0/PHIB SAR_validpin_0/DFFRR_0/a_n930_n400# VDD1v8 sky130_fd_pr__pfet_01v8 ad=0.452887 pd=2.61211 as=0.8 ps=4.8 w=2 l=0.5
X108 VSS RST_N SAR_validpin_0/DFFRR_0/a_3210_n400# VSS sky130_fd_pr__nfet_01v8 ad=0.621084 pd=3.887952 as=0.25 ps=2.25 w=2 l=0.5
X109 SAR_validpin_0/DFFRR_0/a_n420_720# SARclkgen_0/PHIB SAR_validpin_0/DFFRR_0/a_350_n430# VSS sky130_fd_pr__nfet_01v8 ad=1.38 pd=7.08 as=1.2 ps=6.8 w=3 l=0.5
X110 SAR_validpin_0/DFFRR_0/a_2550_720# SARclkgen_0/PHIA SAR_validpin_0/DFFRR_0/a_2090_n400# VDD1v8 sky130_fd_pr__pfet_01v8 ad=0.25 pd=2.25 as=0.92 ps=4.72 w=2 l=0.5
X111 SAR_validpin_0/DFFRR_0/a_350_n430# SARclkgen_0/PHIB SAR_validpin_0/DFFRR_0/a_1130_520# VDD1v8 sky130_fd_pr__pfet_01v8 ad=1.608572 pd=8.971429 as=1.066667 ps=5.866667 w=4 l=0.5
X112 SAR_validpin_0/DFFRR_0/a_1130_520# SAR_validpin_0/DFFRR_0/a_450_n400# VDD1v8 VDD1v8 sky130_fd_pr__pfet_01v8 ad=1.066667 pd=5.866667 as=0.905774 ps=5.224219 w=4 l=0.5
X113 SAR_validpin_0/OR2_1/A SAR_validpin_0/DFFRR_0/a_2600_n430# VSS VSS sky130_fd_pr__nfet_01v8 ad=0.4375 pd=2.425 as=0.310542 ps=1.943976 w=1 l=0.5
X114 SAR_validpin_0/DFFRR_0/a_n560_n400# SARclkgen_0/PHIA VDD1v8 VDD1v8 sky130_fd_pr__pfet_01v8 ad=0.8 pd=4.8 as=0.452887 ps=2.61211 w=2 l=0.5
X115 VSS SARclkgen_0/PHIB SAR_validpin_0/DFFRR_0/a_n930_n400# VSS sky130_fd_pr__nfet_01v8 ad=0.310542 pd=1.943976 as=0.4 ps=2.8 w=1 l=0.5
X116 SAR_validpin_0/OR2_1/A SAR_validpin_0/DFFRR_0/a_2600_n430# VDD1v8 VDD1v8 sky130_fd_pr__pfet_01v8 ad=0.86 pd=4.68 as=0.452887 ps=2.61211 w=2 l=0.5
X117 SAR_validpin_0/DFFRR_0/a_n420_720# SAR_validpin_0/DFFRR_0/a_n930_n400# SAR_validpin_0/DFFRR_0/a_350_n430# VDD1v8 sky130_fd_pr__pfet_01v8 ad=1.328571 pd=7.114286 as=1.206429 ps=6.728571 w=3 l=0.5
X118 SAR_validpin_0/DFFRR_0/a_2600_n430# RST_N VDD1v8 VDD1v8 sky130_fd_pr__pfet_01v8 ad=0.8 pd=4.8 as=0.452887 ps=2.61211 w=2 l=0.5
X119 SAR_validpin_0/DFFRR_0/a_450_n400# SAR_validpin_0/DFFRR_0/a_350_n430# VDD1v8 VDD1v8 sky130_fd_pr__pfet_01v8 ad=0.8 pd=4.64 as=0.452887 ps=2.61211 w=2 l=0.5
X120 SAR_validpin_0/DFFRR_0/a_n560_n400# SARclkgen_0/PHIA VSS VSS sky130_fd_pr__nfet_01v8 ad=0.4 pd=2.8 as=0.310542 ps=1.943976 w=1 l=0.5
X121 VDD1v8 RST_N SAR_validpin_0/DFFRR_0/a_1130_520# VDD1v8 sky130_fd_pr__pfet_01v8 ad=0.905774 pd=5.224219 as=1.066667 ps=5.866667 w=4 l=0.5
X122 VSS shift1v8to5_1/A SAR_validpin_0/DFFRR_0/a_n340_n430# VSS sky130_fd_pr__nfet_01v8 ad=0.310542 pd=1.943976 as=0.4 ps=2.8 w=1 l=0.5
X123 SAR_validpin_0/DFFRR_0/a_2090_n400# SARclkgen_0/PHIA SAR_validpin_0/DFFRR_0/a_450_n400# VSS sky130_fd_pr__nfet_01v8 ad=1.425 pd=7.35 as=1.2 ps=7.2 w=3 l=0.5
X124 VDD1v8 shift1v8to5_1/A SAR_validpin_0/DFFRR_0/a_n340_n430# VDD1v8 sky130_fd_pr__pfet_01v8 ad=0.452887 pd=2.61211 as=0.8 ps=4.8 w=2 l=0.5
X125 SAR_validpin_0/DFFRR_0/a_450_n400# SAR_validpin_0/DFFRR_0/a_350_n430# VSS VSS sky130_fd_pr__nfet_01v8 ad=0.4 pd=2.4 as=0.310542 ps=1.943976 w=1 l=0.5
X126 SAR_validpin_0/DFFRR_0/a_1310_n400# RST_N VSS VSS sky130_fd_pr__nfet_01v8 ad=0.375 pd=3.25 as=0.931626 ps=5.831927 w=3 l=0.5
X127 VDD1v8 SAR_validpin_0/DFFRR_0/a_n340_n430# SAR_validpin_0/DFFRR_0/a_n420_720# VDD1v8 sky130_fd_pr__pfet_01v8 ad=0.452887 pd=2.61211 as=0.885714 ps=4.742857 w=2 l=0.5
X128 SAR_validpin_0/DFFRR_0/a_3210_n400# SAR_validpin_0/DFFRR_0/a_2090_n400# SAR_validpin_0/DFFRR_0/a_2600_n430# VSS sky130_fd_pr__nfet_01v8 ad=0.25 pd=2.25 as=0.8 ps=4.8 w=2 l=0.5
X129 VDD1v8 SAR_validpin_0/DFFRR_0/a_2600_n430# SAR_validpin_0/DFFRR_0/a_2550_720# VDD1v8 sky130_fd_pr__pfet_01v8 ad=0.452887 pd=2.61211 as=0.25 ps=2.25 w=2 l=0.5
X130 SAR_validpin_0/DFFR_1/a_2090_n400# SAR_validpin_0/DFFR_1/a_n50_n400# SAR_validpin_0/DFFR_1/a_450_n400# VDD1v8 sky130_fd_pr__pfet_01v8 ad=1.38 pd=7.08 as=1.2 ps=6.96 w=3 l=0.5
X131 VDD1v8 SAR_validpin_0/DFFR_1/a_2090_n400# SAR_validpin_0/DFFR_1/a_2600_n430# VDD1v8 sky130_fd_pr__pfet_01v8 ad=0.452887 pd=2.61211 as=0.8 ps=4.8 w=2 l=0.5
X132 VSS SARclkgen_0/PHIB SAR_validpin_0/DFFR_1/a_n420_n400# VSS sky130_fd_pr__nfet_01v8 ad=0.310542 pd=1.943976 as=0.4 ps=2.8 w=1 l=0.5
X133 SAR_validpin_0/DFFR_1/a_2550_n400# SAR_validpin_0/DFFR_1/a_n50_n400# SAR_validpin_0/DFFR_1/a_2090_n400# VSS sky130_fd_pr__nfet_01v8 ad=0.125 pd=1.25 as=0.475 ps=2.45 w=1 l=0.5
X134 VSS SAR_validpin_0/DFFR_1/a_2600_n430# SAR_validpin_0/DFFR_1/a_2550_n400# VSS sky130_fd_pr__nfet_01v8 ad=0.310542 pd=1.943976 as=0.125 ps=1.25 w=1 l=0.5
X135 SAR_validpin_0/DFFR_1/a_1460_n400# SAR_validpin_0/DFFR_1/a_450_n400# SAR_validpin_0/DFFR_1/a_1310_n400# VSS sky130_fd_pr__nfet_01v8 ad=0.375 pd=3.25 as=0.375 ps=3.25 w=3 l=0.5
X136 SAR_validpin_0/DFFR_1/a_350_n430# SAR_validpin_0/DFFR_1/a_n420_n400# SAR_validpin_0/DFFR_1/a_1460_n400# VSS sky130_fd_pr__nfet_01v8 ad=1.2 pd=6.8 as=0.375 ps=3.25 w=3 l=0.5
X137 VSS RST_N SAR_validpin_0/DFFR_1/a_3210_n400# VSS sky130_fd_pr__nfet_01v8 ad=0.621084 pd=3.887952 as=0.25 ps=2.25 w=2 l=0.5
X138 SAR_validpin_0/DFFR_1/a_90_n400# SARclkgen_0/PHIB SAR_validpin_0/DFFR_1/a_350_n430# VSS sky130_fd_pr__nfet_01v8 ad=1.425 pd=7.35 as=1.2 ps=6.8 w=3 l=0.5
X139 SAR_validpin_0/DFFR_1/a_n50_n400# SARclkgen_0/PHIA VDD1v8 VDD1v8 sky130_fd_pr__pfet_01v8 ad=0.8 pd=4.8 as=0.452887 ps=2.61211 w=2 l=0.5
X140 SAR_validpin_0/DFFR_1/a_n50_n400# SARclkgen_0/PHIA VSS VSS sky130_fd_pr__nfet_01v8 ad=0.4 pd=2.8 as=0.310542 ps=1.943976 w=1 l=0.5
X141 SAR_validpin_0/DFFR_1/a_2550_720# SARclkgen_0/PHIA SAR_validpin_0/DFFR_1/a_2090_n400# VDD1v8 sky130_fd_pr__pfet_01v8 ad=0.25 pd=2.25 as=0.92 ps=4.72 w=2 l=0.5
X142 SAR_validpin_0/DFFR_1/a_350_n430# SARclkgen_0/PHIB SAR_validpin_0/DFFR_1/a_1130_520# VDD1v8 sky130_fd_pr__pfet_01v8 ad=1.608572 pd=8.971429 as=1.066667 ps=5.866667 w=4 l=0.5
X143 SAR_validpin_0/DFFR_1/a_1130_520# SAR_validpin_0/DFFR_1/a_450_n400# VDD1v8 VDD1v8 sky130_fd_pr__pfet_01v8 ad=1.066667 pd=5.866667 as=0.905774 ps=5.224219 w=4 l=0.5
X144 SAR_validpin_0/OR2_0/B SAR_validpin_0/DFFR_1/a_2600_n430# VSS VSS sky130_fd_pr__nfet_01v8 ad=0.4 pd=2.8 as=0.310542 ps=1.943976 w=1 l=0.5
X145 SAR_validpin_0/OR2_0/B SAR_validpin_0/DFFR_1/a_2600_n430# VDD1v8 VDD1v8 sky130_fd_pr__pfet_01v8 ad=0.8 pd=4.8 as=0.452887 ps=2.61211 w=2 l=0.5
X146 SAR_validpin_0/DFFR_1/a_90_n400# SAR_validpin_0/DFFR_1/a_n420_n400# SAR_validpin_0/DFFR_1/a_350_n430# VDD1v8 sky130_fd_pr__pfet_01v8 ad=1.38 pd=7.08 as=1.206429 ps=6.728571 w=3 l=0.5
X147 SAR_validpin_0/DFFR_1/a_2600_n430# RST_N VDD1v8 VDD1v8 sky130_fd_pr__pfet_01v8 ad=0.8 pd=4.8 as=0.452887 ps=2.61211 w=2 l=0.5
X148 SAR_validpin_0/DFFR_1/a_450_n400# SAR_validpin_0/DFFR_1/a_350_n430# VDD1v8 VDD1v8 sky130_fd_pr__pfet_01v8 ad=0.8 pd=4.64 as=0.452887 ps=2.61211 w=2 l=0.5
X149 VDD1v8 RST_N SAR_validpin_0/DFFR_1/a_1130_520# VDD1v8 sky130_fd_pr__pfet_01v8 ad=0.905774 pd=5.224219 as=1.066667 ps=5.866667 w=4 l=0.5
X150 VSS SAR_validpin_0/OR2_1/B SAR_validpin_0/DFFR_1/a_90_n400# VSS sky130_fd_pr__nfet_01v8 ad=0.310542 pd=1.943976 as=0.475 ps=2.45 w=1 l=0.5
X151 SAR_validpin_0/DFFR_1/a_2090_n400# SARclkgen_0/PHIA SAR_validpin_0/DFFR_1/a_450_n400# VSS sky130_fd_pr__nfet_01v8 ad=1.425 pd=7.35 as=1.2 ps=7.2 w=3 l=0.5
X152 VDD1v8 SAR_validpin_0/OR2_1/B SAR_validpin_0/DFFR_1/a_90_n400# VDD1v8 sky130_fd_pr__pfet_01v8 ad=0.452887 pd=2.61211 as=0.92 ps=4.72 w=2 l=0.5
X153 SAR_validpin_0/DFFR_1/a_450_n400# SAR_validpin_0/DFFR_1/a_350_n430# VSS VSS sky130_fd_pr__nfet_01v8 ad=0.4 pd=2.4 as=0.310542 ps=1.943976 w=1 l=0.5
X154 SAR_validpin_0/DFFR_1/a_1310_n400# RST_N VSS VSS sky130_fd_pr__nfet_01v8 ad=0.375 pd=3.25 as=0.931626 ps=5.831927 w=3 l=0.5
X155 VDD1v8 SARclkgen_0/PHIB SAR_validpin_0/DFFR_1/a_n420_n400# VDD1v8 sky130_fd_pr__pfet_01v8 ad=0.452887 pd=2.61211 as=0.8 ps=4.8 w=2 l=0.5
X156 SAR_validpin_0/DFFR_1/a_3210_n400# SAR_validpin_0/DFFR_1/a_2090_n400# SAR_validpin_0/DFFR_1/a_2600_n430# VSS sky130_fd_pr__nfet_01v8 ad=0.25 pd=2.25 as=0.8 ps=4.8 w=2 l=0.5
X157 VDD1v8 SAR_validpin_0/DFFR_1/a_2600_n430# SAR_validpin_0/DFFR_1/a_2550_720# VDD1v8 sky130_fd_pr__pfet_01v8 ad=0.452887 pd=2.61211 as=0.25 ps=2.25 w=2 l=0.5
X158 SAR_validpin_0/DFFRR_1/a_n420_720# SAR_validpin_0/DFFRR_1/D VDD1v8 VDD1v8 sky130_fd_pr__pfet_01v8 ad=0.885714 pd=4.742857 as=0.452887 ps=2.61211 w=2 l=0.5
X159 SAR_validpin_0/DFFRR_1/a_2090_n400# SAR_validpin_0/DFFRR_1/a_n560_n400# SAR_validpin_0/DFFRR_1/a_450_n400# VDD1v8 sky130_fd_pr__pfet_01v8 ad=1.38 pd=7.08 as=1.2 ps=6.96 w=3 l=0.5
X160 SAR_validpin_0/DFFRR_1/a_n420_720# SAR_validpin_0/DFFRR_1/D SAR_validpin_0/DFFRR_1/a_n240_n400# VSS sky130_fd_pr__nfet_01v8 ad=0.92 pd=4.72 as=0.25 ps=2.25 w=2 l=0.5
X161 VDD1v8 SAR_validpin_0/DFFRR_1/a_2090_n400# SAR_validpin_0/DFFRR_1/a_2600_n430# VDD1v8 sky130_fd_pr__pfet_01v8 ad=0.452887 pd=2.61211 as=0.8 ps=4.8 w=2 l=0.5
X162 SAR_validpin_0/DFFRR_1/a_n240_n400# SAR_validpin_0/DFFRR_1/a_n340_n430# VSS VSS sky130_fd_pr__nfet_01v8 ad=0.25 pd=2.25 as=0.621084 ps=3.887952 w=2 l=0.5
X163 SAR_validpin_0/DFFRR_1/a_2550_n400# SAR_validpin_0/DFFRR_1/a_n560_n400# SAR_validpin_0/DFFRR_1/a_2090_n400# VSS sky130_fd_pr__nfet_01v8 ad=0.125 pd=1.25 as=0.475 ps=2.45 w=1 l=0.5
X164 VSS SAR_validpin_0/DFFRR_1/a_2600_n430# SAR_validpin_0/DFFRR_1/a_2550_n400# VSS sky130_fd_pr__nfet_01v8 ad=0.310542 pd=1.943976 as=0.125 ps=1.25 w=1 l=0.5
X165 SAR_validpin_0/DFFRR_1/a_1460_n400# SAR_validpin_0/DFFRR_1/a_450_n400# SAR_validpin_0/DFFRR_1/a_1310_n400# VSS sky130_fd_pr__nfet_01v8 ad=0.375 pd=3.25 as=0.375 ps=3.25 w=3 l=0.5
X166 SAR_validpin_0/DFFRR_1/a_350_n430# SAR_validpin_0/DFFRR_1/a_n930_n400# SAR_validpin_0/DFFRR_1/a_1460_n400# VSS sky130_fd_pr__nfet_01v8 ad=1.2 pd=6.8 as=0.375 ps=3.25 w=3 l=0.5
X167 VDD1v8 SARclkgen_0/PHIB SAR_validpin_0/DFFRR_1/a_n930_n400# VDD1v8 sky130_fd_pr__pfet_01v8 ad=0.452887 pd=2.61211 as=0.8 ps=4.8 w=2 l=0.5
X168 VSS RST_N SAR_validpin_0/DFFRR_1/a_3210_n400# VSS sky130_fd_pr__nfet_01v8 ad=0.621084 pd=3.887952 as=0.25 ps=2.25 w=2 l=0.5
X169 SAR_validpin_0/DFFRR_1/a_n420_720# SARclkgen_0/PHIB SAR_validpin_0/DFFRR_1/a_350_n430# VSS sky130_fd_pr__nfet_01v8 ad=1.38 pd=7.08 as=1.2 ps=6.8 w=3 l=0.5
X170 SAR_validpin_0/DFFRR_1/a_2550_720# SARclkgen_0/PHIA SAR_validpin_0/DFFRR_1/a_2090_n400# VDD1v8 sky130_fd_pr__pfet_01v8 ad=0.25 pd=2.25 as=0.92 ps=4.72 w=2 l=0.5
X171 SAR_validpin_0/DFFRR_1/a_350_n430# SARclkgen_0/PHIB SAR_validpin_0/DFFRR_1/a_1130_520# VDD1v8 sky130_fd_pr__pfet_01v8 ad=1.608572 pd=8.971429 as=1.066667 ps=5.866667 w=4 l=0.5
X172 SAR_validpin_0/DFFRR_1/a_1130_520# SAR_validpin_0/DFFRR_1/a_450_n400# VDD1v8 VDD1v8 sky130_fd_pr__pfet_01v8 ad=1.066667 pd=5.866667 as=0.905774 ps=5.224219 w=4 l=0.5
X173 SAR_validpin_0/OR2_0/A SAR_validpin_0/DFFRR_1/a_2600_n430# VSS VSS sky130_fd_pr__nfet_01v8 ad=0.4375 pd=2.425 as=0.310542 ps=1.943976 w=1 l=0.5
X174 SAR_validpin_0/DFFRR_1/a_n560_n400# SARclkgen_0/PHIA VDD1v8 VDD1v8 sky130_fd_pr__pfet_01v8 ad=0.8 pd=4.8 as=0.452887 ps=2.61211 w=2 l=0.5
X175 VSS SARclkgen_0/PHIB SAR_validpin_0/DFFRR_1/a_n930_n400# VSS sky130_fd_pr__nfet_01v8 ad=0.310542 pd=1.943976 as=0.4 ps=2.8 w=1 l=0.5
X176 SAR_validpin_0/OR2_0/A SAR_validpin_0/DFFRR_1/a_2600_n430# VDD1v8 VDD1v8 sky130_fd_pr__pfet_01v8 ad=0.86 pd=4.68 as=0.452887 ps=2.61211 w=2 l=0.5
X177 SAR_validpin_0/DFFRR_1/a_n420_720# SAR_validpin_0/DFFRR_1/a_n930_n400# SAR_validpin_0/DFFRR_1/a_350_n430# VDD1v8 sky130_fd_pr__pfet_01v8 ad=1.328571 pd=7.114286 as=1.206429 ps=6.728571 w=3 l=0.5
X178 SAR_validpin_0/DFFRR_1/a_2600_n430# RST_N VDD1v8 VDD1v8 sky130_fd_pr__pfet_01v8 ad=0.8 pd=4.8 as=0.452887 ps=2.61211 w=2 l=0.5
X179 SAR_validpin_0/DFFRR_1/a_450_n400# SAR_validpin_0/DFFRR_1/a_350_n430# VDD1v8 VDD1v8 sky130_fd_pr__pfet_01v8 ad=0.8 pd=4.64 as=0.452887 ps=2.61211 w=2 l=0.5
X180 SAR_validpin_0/DFFRR_1/a_n560_n400# SARclkgen_0/PHIA VSS VSS sky130_fd_pr__nfet_01v8 ad=0.4 pd=2.8 as=0.310542 ps=1.943976 w=1 l=0.5
X181 VDD1v8 RST_N SAR_validpin_0/DFFRR_1/a_1130_520# VDD1v8 sky130_fd_pr__pfet_01v8 ad=0.905774 pd=5.224219 as=1.066667 ps=5.866667 w=4 l=0.5
X182 VSS shift1v8to5_1/A SAR_validpin_0/DFFRR_1/a_n340_n430# VSS sky130_fd_pr__nfet_01v8 ad=0.310542 pd=1.943976 as=0.4 ps=2.8 w=1 l=0.5
X183 SAR_validpin_0/DFFRR_1/a_2090_n400# SARclkgen_0/PHIA SAR_validpin_0/DFFRR_1/a_450_n400# VSS sky130_fd_pr__nfet_01v8 ad=1.425 pd=7.35 as=1.2 ps=7.2 w=3 l=0.5
X184 VDD1v8 shift1v8to5_1/A SAR_validpin_0/DFFRR_1/a_n340_n430# VDD1v8 sky130_fd_pr__pfet_01v8 ad=0.452887 pd=2.61211 as=0.8 ps=4.8 w=2 l=0.5
X185 SAR_validpin_0/DFFRR_1/a_450_n400# SAR_validpin_0/DFFRR_1/a_350_n430# VSS VSS sky130_fd_pr__nfet_01v8 ad=0.4 pd=2.4 as=0.310542 ps=1.943976 w=1 l=0.5
X186 SAR_validpin_0/DFFRR_1/a_1310_n400# RST_N VSS VSS sky130_fd_pr__nfet_01v8 ad=0.375 pd=3.25 as=0.931626 ps=5.831927 w=3 l=0.5
X187 VDD1v8 SAR_validpin_0/DFFRR_1/a_n340_n430# SAR_validpin_0/DFFRR_1/a_n420_720# VDD1v8 sky130_fd_pr__pfet_01v8 ad=0.452887 pd=2.61211 as=0.885714 ps=4.742857 w=2 l=0.5
X188 SAR_validpin_0/DFFRR_1/a_3210_n400# SAR_validpin_0/DFFRR_1/a_2090_n400# SAR_validpin_0/DFFRR_1/a_2600_n430# VSS sky130_fd_pr__nfet_01v8 ad=0.25 pd=2.25 as=0.8 ps=4.8 w=2 l=0.5
X189 VDD1v8 SAR_validpin_0/DFFRR_1/a_2600_n430# SAR_validpin_0/DFFRR_1/a_2550_720# VDD1v8 sky130_fd_pr__pfet_01v8 ad=0.452887 pd=2.61211 as=0.25 ps=2.25 w=2 l=0.5
X190 SAR_validpin_0/DFFR_3/a_2090_n400# SAR_validpin_0/DFFR_3/a_n50_n400# SAR_validpin_0/DFFR_3/a_450_n400# VDD1v8 sky130_fd_pr__pfet_01v8 ad=1.38 pd=7.08 as=1.2 ps=6.96 w=3 l=0.5
X191 VDD1v8 SAR_validpin_0/DFFR_3/a_2090_n400# SAR_validpin_0/DFFR_3/a_2600_n430# VDD1v8 sky130_fd_pr__pfet_01v8 ad=0.452887 pd=2.61211 as=0.8 ps=4.8 w=2 l=0.5
X192 VSS SAR_validpin_0/AND2_1/Y SAR_validpin_0/DFFR_3/a_n420_n400# VSS sky130_fd_pr__nfet_01v8 ad=0.310542 pd=1.943976 as=0.4 ps=2.8 w=1 l=0.5
X193 SAR_validpin_0/DFFR_3/a_2550_n400# SAR_validpin_0/DFFR_3/a_n50_n400# SAR_validpin_0/DFFR_3/a_2090_n400# VSS sky130_fd_pr__nfet_01v8 ad=0.125 pd=1.25 as=0.475 ps=2.45 w=1 l=0.5
X194 VSS SAR_validpin_0/DFFR_3/a_2600_n430# SAR_validpin_0/DFFR_3/a_2550_n400# VSS sky130_fd_pr__nfet_01v8 ad=0.310542 pd=1.943976 as=0.125 ps=1.25 w=1 l=0.5
X195 SAR_validpin_0/DFFR_3/a_1460_n400# SAR_validpin_0/DFFR_3/a_450_n400# SAR_validpin_0/DFFR_3/a_1310_n400# VSS sky130_fd_pr__nfet_01v8 ad=0.375 pd=3.25 as=0.375 ps=3.25 w=3 l=0.5
X196 SAR_validpin_0/DFFR_3/a_350_n430# SAR_validpin_0/DFFR_3/a_n420_n400# SAR_validpin_0/DFFR_3/a_1460_n400# VSS sky130_fd_pr__nfet_01v8 ad=1.2 pd=6.8 as=0.375 ps=3.25 w=3 l=0.5
X197 VSS RST_N SAR_validpin_0/DFFR_3/a_3210_n400# VSS sky130_fd_pr__nfet_01v8 ad=0.621084 pd=3.887952 as=0.25 ps=2.25 w=2 l=0.5
X198 SAR_validpin_0/DFFR_3/a_90_n400# SAR_validpin_0/AND2_1/Y SAR_validpin_0/DFFR_3/a_350_n430# VSS sky130_fd_pr__nfet_01v8 ad=1.425 pd=7.35 as=1.2 ps=6.8 w=3 l=0.5
X199 SAR_validpin_0/DFFR_3/a_n50_n400# SAR_validpin_0/AND2_0/Y VDD1v8 VDD1v8 sky130_fd_pr__pfet_01v8 ad=0.8 pd=4.8 as=0.452887 ps=2.61211 w=2 l=0.5
X200 SAR_validpin_0/DFFR_3/a_n50_n400# SAR_validpin_0/AND2_0/Y VSS VSS sky130_fd_pr__nfet_01v8 ad=0.4 pd=2.8 as=0.310542 ps=1.943976 w=1 l=0.5
X201 SAR_validpin_0/DFFR_3/a_2550_720# SAR_validpin_0/AND2_0/Y SAR_validpin_0/DFFR_3/a_2090_n400# VDD1v8 sky130_fd_pr__pfet_01v8 ad=0.25 pd=2.25 as=0.92 ps=4.72 w=2 l=0.5
X202 SAR_validpin_0/DFFR_3/a_350_n430# SAR_validpin_0/AND2_1/Y SAR_validpin_0/DFFR_3/a_1130_520# VDD1v8 sky130_fd_pr__pfet_01v8 ad=1.608572 pd=8.971429 as=1.066667 ps=5.866667 w=4 l=0.5
X203 SAR_validpin_0/DFFR_3/a_1130_520# SAR_validpin_0/DFFR_3/a_450_n400# VDD1v8 VDD1v8 sky130_fd_pr__pfet_01v8 ad=1.066667 pd=5.866667 as=0.905774 ps=5.224219 w=4 l=0.5
X204 ADC_OUT0 SAR_validpin_0/DFFR_3/a_2600_n430# VSS VSS sky130_fd_pr__nfet_01v8 ad=0.4 pd=2.8 as=0.310542 ps=1.943976 w=1 l=0.5
X205 ADC_OUT0 SAR_validpin_0/DFFR_3/a_2600_n430# VDD1v8 VDD1v8 sky130_fd_pr__pfet_01v8 ad=0.8 pd=4.8 as=0.452887 ps=2.61211 w=2 l=0.5
X206 SAR_validpin_0/DFFR_3/a_90_n400# SAR_validpin_0/DFFR_3/a_n420_n400# SAR_validpin_0/DFFR_3/a_350_n430# VDD1v8 sky130_fd_pr__pfet_01v8 ad=1.38 pd=7.08 as=1.206429 ps=6.728571 w=3 l=0.5
X207 SAR_validpin_0/DFFR_3/a_2600_n430# RST_N VDD1v8 VDD1v8 sky130_fd_pr__pfet_01v8 ad=0.8 pd=4.8 as=0.452887 ps=2.61211 w=2 l=0.5
X208 SAR_validpin_0/DFFR_3/a_450_n400# SAR_validpin_0/DFFR_3/a_350_n430# VDD1v8 VDD1v8 sky130_fd_pr__pfet_01v8 ad=0.8 pd=4.64 as=0.452887 ps=2.61211 w=2 l=0.5
X209 VDD1v8 RST_N SAR_validpin_0/DFFR_3/a_1130_520# VDD1v8 sky130_fd_pr__pfet_01v8 ad=0.905774 pd=5.224219 as=1.066667 ps=5.866667 w=4 l=0.5
X210 VSS SAR_validpin_0/DFFR_3/D SAR_validpin_0/DFFR_3/a_90_n400# VSS sky130_fd_pr__nfet_01v8 ad=0.310542 pd=1.943976 as=0.475 ps=2.45 w=1 l=0.5
X211 SAR_validpin_0/DFFR_3/a_2090_n400# SAR_validpin_0/AND2_0/Y SAR_validpin_0/DFFR_3/a_450_n400# VSS sky130_fd_pr__nfet_01v8 ad=1.425 pd=7.35 as=1.2 ps=7.2 w=3 l=0.5
X212 VDD1v8 SAR_validpin_0/DFFR_3/D SAR_validpin_0/DFFR_3/a_90_n400# VDD1v8 sky130_fd_pr__pfet_01v8 ad=0.452887 pd=2.61211 as=0.92 ps=4.72 w=2 l=0.5
X213 SAR_validpin_0/DFFR_3/a_450_n400# SAR_validpin_0/DFFR_3/a_350_n430# VSS VSS sky130_fd_pr__nfet_01v8 ad=0.4 pd=2.4 as=0.310542 ps=1.943976 w=1 l=0.5
X214 SAR_validpin_0/DFFR_3/a_1310_n400# RST_N VSS VSS sky130_fd_pr__nfet_01v8 ad=0.375 pd=3.25 as=0.931626 ps=5.831927 w=3 l=0.5
X215 VDD1v8 SAR_validpin_0/AND2_1/Y SAR_validpin_0/DFFR_3/a_n420_n400# VDD1v8 sky130_fd_pr__pfet_01v8 ad=0.452887 pd=2.61211 as=0.8 ps=4.8 w=2 l=0.5
X216 SAR_validpin_0/DFFR_3/a_3210_n400# SAR_validpin_0/DFFR_3/a_2090_n400# SAR_validpin_0/DFFR_3/a_2600_n430# VSS sky130_fd_pr__nfet_01v8 ad=0.25 pd=2.25 as=0.8 ps=4.8 w=2 l=0.5
X217 VDD1v8 SAR_validpin_0/DFFR_3/a_2600_n430# SAR_validpin_0/DFFR_3/a_2550_720# VDD1v8 sky130_fd_pr__pfet_01v8 ad=0.452887 pd=2.61211 as=0.25 ps=2.25 w=2 l=0.5
X218 SAR_validpin_0/DFFR_2/a_2090_n400# SAR_validpin_0/DFFR_2/a_n50_n400# SAR_validpin_0/DFFR_2/a_450_n400# VDD1v8 sky130_fd_pr__pfet_01v8 ad=1.38 pd=7.08 as=1.2 ps=6.96 w=3 l=0.5
X219 VDD1v8 SAR_validpin_0/DFFR_2/a_2090_n400# SAR_validpin_0/DFFR_2/a_2600_n430# VDD1v8 sky130_fd_pr__pfet_01v8 ad=0.452887 pd=2.61211 as=0.8 ps=4.8 w=2 l=0.5
X220 VSS SARclkgen_0/PHIB SAR_validpin_0/DFFR_2/a_n420_n400# VSS sky130_fd_pr__nfet_01v8 ad=0.310542 pd=1.943976 as=0.4 ps=2.8 w=1 l=0.5
X221 SAR_validpin_0/DFFR_2/a_2550_n400# SAR_validpin_0/DFFR_2/a_n50_n400# SAR_validpin_0/DFFR_2/a_2090_n400# VSS sky130_fd_pr__nfet_01v8 ad=0.125 pd=1.25 as=0.475 ps=2.45 w=1 l=0.5
X222 VSS SAR_validpin_0/DFFR_2/a_2600_n430# SAR_validpin_0/DFFR_2/a_2550_n400# VSS sky130_fd_pr__nfet_01v8 ad=0.310542 pd=1.943976 as=0.125 ps=1.25 w=1 l=0.5
X223 SAR_validpin_0/DFFR_2/a_1460_n400# SAR_validpin_0/DFFR_2/a_450_n400# SAR_validpin_0/DFFR_2/a_1310_n400# VSS sky130_fd_pr__nfet_01v8 ad=0.375 pd=3.25 as=0.375 ps=3.25 w=3 l=0.5
X224 SAR_validpin_0/DFFR_2/a_350_n430# SAR_validpin_0/DFFR_2/a_n420_n400# SAR_validpin_0/DFFR_2/a_1460_n400# VSS sky130_fd_pr__nfet_01v8 ad=1.2 pd=6.8 as=0.375 ps=3.25 w=3 l=0.5
X225 VSS RST_N SAR_validpin_0/DFFR_2/a_3210_n400# VSS sky130_fd_pr__nfet_01v8 ad=0.621084 pd=3.887952 as=0.25 ps=2.25 w=2 l=0.5
X226 SAR_validpin_0/DFFR_2/a_90_n400# SARclkgen_0/PHIB SAR_validpin_0/DFFR_2/a_350_n430# VSS sky130_fd_pr__nfet_01v8 ad=1.425 pd=7.35 as=1.2 ps=6.8 w=3 l=0.5
X227 SAR_validpin_0/DFFR_2/a_n50_n400# SARclkgen_0/PHIA VDD1v8 VDD1v8 sky130_fd_pr__pfet_01v8 ad=0.8 pd=4.8 as=0.452887 ps=2.61211 w=2 l=0.5
X228 SAR_validpin_0/DFFR_2/a_n50_n400# SARclkgen_0/PHIA VSS VSS sky130_fd_pr__nfet_01v8 ad=0.4 pd=2.8 as=0.310542 ps=1.943976 w=1 l=0.5
X229 SAR_validpin_0/DFFR_2/a_2550_720# SARclkgen_0/PHIA SAR_validpin_0/DFFR_2/a_2090_n400# VDD1v8 sky130_fd_pr__pfet_01v8 ad=0.25 pd=2.25 as=0.92 ps=4.72 w=2 l=0.5
X230 SAR_validpin_0/DFFR_2/a_350_n430# SARclkgen_0/PHIB SAR_validpin_0/DFFR_2/a_1130_520# VDD1v8 sky130_fd_pr__pfet_01v8 ad=1.608572 pd=8.971429 as=1.066667 ps=5.866667 w=4 l=0.5
X231 SAR_validpin_0/DFFR_2/a_1130_520# SAR_validpin_0/DFFR_2/a_450_n400# VDD1v8 VDD1v8 sky130_fd_pr__pfet_01v8 ad=1.066667 pd=5.866667 as=0.905774 ps=5.224219 w=4 l=0.5
X232 shift1v8to5_1/A SAR_validpin_0/DFFR_2/a_2600_n430# VSS VSS sky130_fd_pr__nfet_01v8 ad=0.4 pd=2.8 as=0.310542 ps=1.943976 w=1 l=0.5
X233 shift1v8to5_1/A SAR_validpin_0/DFFR_2/a_2600_n430# VDD1v8 VDD1v8 sky130_fd_pr__pfet_01v8 ad=0.8 pd=4.8 as=0.452887 ps=2.61211 w=2 l=0.5
X234 SAR_validpin_0/DFFR_2/a_90_n400# SAR_validpin_0/DFFR_2/a_n420_n400# SAR_validpin_0/DFFR_2/a_350_n430# VDD1v8 sky130_fd_pr__pfet_01v8 ad=1.38 pd=7.08 as=1.206429 ps=6.728571 w=3 l=0.5
X235 SAR_validpin_0/DFFR_2/a_2600_n430# RST_N VDD1v8 VDD1v8 sky130_fd_pr__pfet_01v8 ad=0.8 pd=4.8 as=0.452887 ps=2.61211 w=2 l=0.5
X236 SAR_validpin_0/DFFR_2/a_450_n400# SAR_validpin_0/DFFR_2/a_350_n430# VDD1v8 VDD1v8 sky130_fd_pr__pfet_01v8 ad=0.8 pd=4.64 as=0.452887 ps=2.61211 w=2 l=0.5
X237 VDD1v8 RST_N SAR_validpin_0/DFFR_2/a_1130_520# VDD1v8 sky130_fd_pr__pfet_01v8 ad=0.905774 pd=5.224219 as=1.066667 ps=5.866667 w=4 l=0.5
X238 VSS SAR_validpin_0/OR2_0/B SAR_validpin_0/DFFR_2/a_90_n400# VSS sky130_fd_pr__nfet_01v8 ad=0.310542 pd=1.943976 as=0.475 ps=2.45 w=1 l=0.5
X239 SAR_validpin_0/DFFR_2/a_2090_n400# SARclkgen_0/PHIA SAR_validpin_0/DFFR_2/a_450_n400# VSS sky130_fd_pr__nfet_01v8 ad=1.425 pd=7.35 as=1.2 ps=7.2 w=3 l=0.5
X240 VDD1v8 SAR_validpin_0/OR2_0/B SAR_validpin_0/DFFR_2/a_90_n400# VDD1v8 sky130_fd_pr__pfet_01v8 ad=0.452887 pd=2.61211 as=0.92 ps=4.72 w=2 l=0.5
X241 SAR_validpin_0/DFFR_2/a_450_n400# SAR_validpin_0/DFFR_2/a_350_n430# VSS VSS sky130_fd_pr__nfet_01v8 ad=0.4 pd=2.4 as=0.310542 ps=1.943976 w=1 l=0.5
X242 SAR_validpin_0/DFFR_2/a_1310_n400# RST_N VSS VSS sky130_fd_pr__nfet_01v8 ad=0.375 pd=3.25 as=0.931626 ps=5.831927 w=3 l=0.5
X243 VDD1v8 SARclkgen_0/PHIB SAR_validpin_0/DFFR_2/a_n420_n400# VDD1v8 sky130_fd_pr__pfet_01v8 ad=0.452887 pd=2.61211 as=0.8 ps=4.8 w=2 l=0.5
X244 SAR_validpin_0/DFFR_2/a_3210_n400# SAR_validpin_0/DFFR_2/a_2090_n400# SAR_validpin_0/DFFR_2/a_2600_n430# VSS sky130_fd_pr__nfet_01v8 ad=0.25 pd=2.25 as=0.8 ps=4.8 w=2 l=0.5
X245 VDD1v8 SAR_validpin_0/DFFR_2/a_2600_n430# SAR_validpin_0/DFFR_2/a_2550_720# VDD1v8 sky130_fd_pr__pfet_01v8 ad=0.452887 pd=2.61211 as=0.25 ps=2.25 w=2 l=0.5
X246 SAR_validpin_0/DFFR_4/a_2090_n400# SAR_validpin_0/DFFR_4/a_n50_n400# SAR_validpin_0/DFFR_4/a_450_n400# VDD1v8 sky130_fd_pr__pfet_01v8 ad=1.38 pd=7.08 as=1.2 ps=6.96 w=3 l=0.5
X247 VDD1v8 SAR_validpin_0/DFFR_4/a_2090_n400# SAR_validpin_0/DFFR_4/a_2600_n430# VDD1v8 sky130_fd_pr__pfet_01v8 ad=0.452887 pd=2.61211 as=0.8 ps=4.8 w=2 l=0.5
X248 VSS SAR_validpin_0/AND2_1/Y SAR_validpin_0/DFFR_4/a_n420_n400# VSS sky130_fd_pr__nfet_01v8 ad=0.310542 pd=1.943976 as=0.4 ps=2.8 w=1 l=0.5
X249 SAR_validpin_0/DFFR_4/a_2550_n400# SAR_validpin_0/DFFR_4/a_n50_n400# SAR_validpin_0/DFFR_4/a_2090_n400# VSS sky130_fd_pr__nfet_01v8 ad=0.125 pd=1.25 as=0.475 ps=2.45 w=1 l=0.5
X250 VSS SAR_validpin_0/DFFR_4/a_2600_n430# SAR_validpin_0/DFFR_4/a_2550_n400# VSS sky130_fd_pr__nfet_01v8 ad=0.310542 pd=1.943976 as=0.125 ps=1.25 w=1 l=0.5
X251 SAR_validpin_0/DFFR_4/a_1460_n400# SAR_validpin_0/DFFR_4/a_450_n400# SAR_validpin_0/DFFR_4/a_1310_n400# VSS sky130_fd_pr__nfet_01v8 ad=0.375 pd=3.25 as=0.375 ps=3.25 w=3 l=0.5
X252 SAR_validpin_0/DFFR_4/a_350_n430# SAR_validpin_0/DFFR_4/a_n420_n400# SAR_validpin_0/DFFR_4/a_1460_n400# VSS sky130_fd_pr__nfet_01v8 ad=1.2 pd=6.8 as=0.375 ps=3.25 w=3 l=0.5
X253 VSS RST_N SAR_validpin_0/DFFR_4/a_3210_n400# VSS sky130_fd_pr__nfet_01v8 ad=0.621084 pd=3.887952 as=0.25 ps=2.25 w=2 l=0.5
X254 SAR_validpin_0/DFFR_4/a_90_n400# SAR_validpin_0/AND2_1/Y SAR_validpin_0/DFFR_4/a_350_n430# VSS sky130_fd_pr__nfet_01v8 ad=1.425 pd=7.35 as=1.2 ps=6.8 w=3 l=0.5
X255 SAR_validpin_0/DFFR_4/a_n50_n400# SAR_validpin_0/AND2_0/Y VDD1v8 VDD1v8 sky130_fd_pr__pfet_01v8 ad=0.8 pd=4.8 as=0.452887 ps=2.61211 w=2 l=0.5
X256 SAR_validpin_0/DFFR_4/a_n50_n400# SAR_validpin_0/AND2_0/Y VSS VSS sky130_fd_pr__nfet_01v8 ad=0.4 pd=2.8 as=0.310542 ps=1.943976 w=1 l=0.5
X257 SAR_validpin_0/DFFR_4/a_2550_720# SAR_validpin_0/AND2_0/Y SAR_validpin_0/DFFR_4/a_2090_n400# VDD1v8 sky130_fd_pr__pfet_01v8 ad=0.25 pd=2.25 as=0.92 ps=4.72 w=2 l=0.5
X258 SAR_validpin_0/DFFR_4/a_350_n430# SAR_validpin_0/AND2_1/Y SAR_validpin_0/DFFR_4/a_1130_520# VDD1v8 sky130_fd_pr__pfet_01v8 ad=1.608572 pd=8.971429 as=1.066667 ps=5.866667 w=4 l=0.5
X259 SAR_validpin_0/DFFR_4/a_1130_520# SAR_validpin_0/DFFR_4/a_450_n400# VDD1v8 VDD1v8 sky130_fd_pr__pfet_01v8 ad=1.066667 pd=5.866667 as=0.905774 ps=5.224219 w=4 l=0.5
X260 ADC_OUT1 SAR_validpin_0/DFFR_4/a_2600_n430# VSS VSS sky130_fd_pr__nfet_01v8 ad=0.4 pd=2.8 as=0.310542 ps=1.943976 w=1 l=0.5
X261 ADC_OUT1 SAR_validpin_0/DFFR_4/a_2600_n430# VDD1v8 VDD1v8 sky130_fd_pr__pfet_01v8 ad=0.8 pd=4.8 as=0.452887 ps=2.61211 w=2 l=0.5
X262 SAR_validpin_0/DFFR_4/a_90_n400# SAR_validpin_0/DFFR_4/a_n420_n400# SAR_validpin_0/DFFR_4/a_350_n430# VDD1v8 sky130_fd_pr__pfet_01v8 ad=1.38 pd=7.08 as=1.206429 ps=6.728571 w=3 l=0.5
X263 SAR_validpin_0/DFFR_4/a_2600_n430# RST_N VDD1v8 VDD1v8 sky130_fd_pr__pfet_01v8 ad=0.8 pd=4.8 as=0.452887 ps=2.61211 w=2 l=0.5
X264 SAR_validpin_0/DFFR_4/a_450_n400# SAR_validpin_0/DFFR_4/a_350_n430# VDD1v8 VDD1v8 sky130_fd_pr__pfet_01v8 ad=0.8 pd=4.64 as=0.452887 ps=2.61211 w=2 l=0.5
X265 VDD1v8 RST_N SAR_validpin_0/DFFR_4/a_1130_520# VDD1v8 sky130_fd_pr__pfet_01v8 ad=0.905774 pd=5.224219 as=1.066667 ps=5.866667 w=4 l=0.5
X266 VSS SAR_validpin_0/OR2_0/A SAR_validpin_0/DFFR_4/a_90_n400# VSS sky130_fd_pr__nfet_01v8 ad=0.310542 pd=1.943976 as=0.475 ps=2.45 w=1 l=0.5
X267 SAR_validpin_0/DFFR_4/a_2090_n400# SAR_validpin_0/AND2_0/Y SAR_validpin_0/DFFR_4/a_450_n400# VSS sky130_fd_pr__nfet_01v8 ad=1.425 pd=7.35 as=1.2 ps=7.2 w=3 l=0.5
X268 VDD1v8 SAR_validpin_0/OR2_0/A SAR_validpin_0/DFFR_4/a_90_n400# VDD1v8 sky130_fd_pr__pfet_01v8 ad=0.452887 pd=2.61211 as=0.92 ps=4.72 w=2 l=0.5
X269 SAR_validpin_0/DFFR_4/a_450_n400# SAR_validpin_0/DFFR_4/a_350_n430# VSS VSS sky130_fd_pr__nfet_01v8 ad=0.4 pd=2.4 as=0.310542 ps=1.943976 w=1 l=0.5
X270 SAR_validpin_0/DFFR_4/a_1310_n400# RST_N VSS VSS sky130_fd_pr__nfet_01v8 ad=0.375 pd=3.25 as=0.931626 ps=5.831927 w=3 l=0.5
X271 VDD1v8 SAR_validpin_0/AND2_1/Y SAR_validpin_0/DFFR_4/a_n420_n400# VDD1v8 sky130_fd_pr__pfet_01v8 ad=0.452887 pd=2.61211 as=0.8 ps=4.8 w=2 l=0.5
X272 SAR_validpin_0/DFFR_4/a_3210_n400# SAR_validpin_0/DFFR_4/a_2090_n400# SAR_validpin_0/DFFR_4/a_2600_n430# VSS sky130_fd_pr__nfet_01v8 ad=0.25 pd=2.25 as=0.8 ps=4.8 w=2 l=0.5
X273 VDD1v8 SAR_validpin_0/DFFR_4/a_2600_n430# SAR_validpin_0/DFFR_4/a_2550_720# VDD1v8 sky130_fd_pr__pfet_01v8 ad=0.452887 pd=2.61211 as=0.25 ps=2.25 w=2 l=0.5
X274 SAR_validpin_0/DFFR_5/a_2090_n400# SAR_validpin_0/DFFR_5/a_n50_n400# SAR_validpin_0/DFFR_5/a_450_n400# VDD1v8 sky130_fd_pr__pfet_01v8 ad=1.38 pd=7.08 as=1.2 ps=6.96 w=3 l=0.5
X275 VDD1v8 SAR_validpin_0/DFFR_5/a_2090_n400# SAR_validpin_0/DFFR_5/a_2600_n430# VDD1v8 sky130_fd_pr__pfet_01v8 ad=0.452887 pd=2.61211 as=0.8 ps=4.8 w=2 l=0.5
X276 VSS SAR_validpin_0/AND2_1/Y SAR_validpin_0/DFFR_5/a_n420_n400# VSS sky130_fd_pr__nfet_01v8 ad=0.310542 pd=1.943976 as=0.4 ps=2.8 w=1 l=0.5
X277 SAR_validpin_0/DFFR_5/a_2550_n400# SAR_validpin_0/DFFR_5/a_n50_n400# SAR_validpin_0/DFFR_5/a_2090_n400# VSS sky130_fd_pr__nfet_01v8 ad=0.125 pd=1.25 as=0.475 ps=2.45 w=1 l=0.5
X278 VSS SAR_validpin_0/DFFR_5/a_2600_n430# SAR_validpin_0/DFFR_5/a_2550_n400# VSS sky130_fd_pr__nfet_01v8 ad=0.310542 pd=1.943976 as=0.125 ps=1.25 w=1 l=0.5
X279 SAR_validpin_0/DFFR_5/a_1460_n400# SAR_validpin_0/DFFR_5/a_450_n400# SAR_validpin_0/DFFR_5/a_1310_n400# VSS sky130_fd_pr__nfet_01v8 ad=0.375 pd=3.25 as=0.375 ps=3.25 w=3 l=0.5
X280 SAR_validpin_0/DFFR_5/a_350_n430# SAR_validpin_0/DFFR_5/a_n420_n400# SAR_validpin_0/DFFR_5/a_1460_n400# VSS sky130_fd_pr__nfet_01v8 ad=1.2 pd=6.8 as=0.375 ps=3.25 w=3 l=0.5
X281 VSS RST_N SAR_validpin_0/DFFR_5/a_3210_n400# VSS sky130_fd_pr__nfet_01v8 ad=0.621084 pd=3.887952 as=0.25 ps=2.25 w=2 l=0.5
X282 SAR_validpin_0/DFFR_5/a_90_n400# SAR_validpin_0/AND2_1/Y SAR_validpin_0/DFFR_5/a_350_n430# VSS sky130_fd_pr__nfet_01v8 ad=1.425 pd=7.35 as=1.2 ps=6.8 w=3 l=0.5
X283 SAR_validpin_0/DFFR_5/a_n50_n400# SAR_validpin_0/AND2_0/Y VDD1v8 VDD1v8 sky130_fd_pr__pfet_01v8 ad=0.8 pd=4.8 as=0.452887 ps=2.61211 w=2 l=0.5
X284 SAR_validpin_0/DFFR_5/a_n50_n400# SAR_validpin_0/AND2_0/Y VSS VSS sky130_fd_pr__nfet_01v8 ad=0.4 pd=2.8 as=0.310542 ps=1.943976 w=1 l=0.5
X285 SAR_validpin_0/DFFR_5/a_2550_720# SAR_validpin_0/AND2_0/Y SAR_validpin_0/DFFR_5/a_2090_n400# VDD1v8 sky130_fd_pr__pfet_01v8 ad=0.25 pd=2.25 as=0.92 ps=4.72 w=2 l=0.5
X286 SAR_validpin_0/DFFR_5/a_350_n430# SAR_validpin_0/AND2_1/Y SAR_validpin_0/DFFR_5/a_1130_520# VDD1v8 sky130_fd_pr__pfet_01v8 ad=1.608572 pd=8.971429 as=1.066667 ps=5.866667 w=4 l=0.5
X287 SAR_validpin_0/DFFR_5/a_1130_520# SAR_validpin_0/DFFR_5/a_450_n400# VDD1v8 VDD1v8 sky130_fd_pr__pfet_01v8 ad=1.066667 pd=5.866667 as=0.905774 ps=5.224219 w=4 l=0.5
X288 ADC_OUT2 SAR_validpin_0/DFFR_5/a_2600_n430# VSS VSS sky130_fd_pr__nfet_01v8 ad=0.4 pd=2.8 as=0.310542 ps=1.943976 w=1 l=0.5
X289 ADC_OUT2 SAR_validpin_0/DFFR_5/a_2600_n430# VDD1v8 VDD1v8 sky130_fd_pr__pfet_01v8 ad=0.8 pd=4.8 as=0.452887 ps=2.61211 w=2 l=0.5
X290 SAR_validpin_0/DFFR_5/a_90_n400# SAR_validpin_0/DFFR_5/a_n420_n400# SAR_validpin_0/DFFR_5/a_350_n430# VDD1v8 sky130_fd_pr__pfet_01v8 ad=1.38 pd=7.08 as=1.206429 ps=6.728571 w=3 l=0.5
X291 SAR_validpin_0/DFFR_5/a_2600_n430# RST_N VDD1v8 VDD1v8 sky130_fd_pr__pfet_01v8 ad=0.8 pd=4.8 as=0.452887 ps=2.61211 w=2 l=0.5
X292 SAR_validpin_0/DFFR_5/a_450_n400# SAR_validpin_0/DFFR_5/a_350_n430# VDD1v8 VDD1v8 sky130_fd_pr__pfet_01v8 ad=0.8 pd=4.64 as=0.452887 ps=2.61211 w=2 l=0.5
X293 VDD1v8 RST_N SAR_validpin_0/DFFR_5/a_1130_520# VDD1v8 sky130_fd_pr__pfet_01v8 ad=0.905774 pd=5.224219 as=1.066667 ps=5.866667 w=4 l=0.5
X294 VSS SAR_validpin_0/OR2_1/A SAR_validpin_0/DFFR_5/a_90_n400# VSS sky130_fd_pr__nfet_01v8 ad=0.310542 pd=1.943976 as=0.475 ps=2.45 w=1 l=0.5
X295 SAR_validpin_0/DFFR_5/a_2090_n400# SAR_validpin_0/AND2_0/Y SAR_validpin_0/DFFR_5/a_450_n400# VSS sky130_fd_pr__nfet_01v8 ad=1.425 pd=7.35 as=1.2 ps=7.2 w=3 l=0.5
X296 VDD1v8 SAR_validpin_0/OR2_1/A SAR_validpin_0/DFFR_5/a_90_n400# VDD1v8 sky130_fd_pr__pfet_01v8 ad=0.452887 pd=2.61211 as=0.92 ps=4.72 w=2 l=0.5
X297 SAR_validpin_0/DFFR_5/a_450_n400# SAR_validpin_0/DFFR_5/a_350_n430# VSS VSS sky130_fd_pr__nfet_01v8 ad=0.4 pd=2.4 as=0.310542 ps=1.943976 w=1 l=0.5
X298 SAR_validpin_0/DFFR_5/a_1310_n400# RST_N VSS VSS sky130_fd_pr__nfet_01v8 ad=0.375 pd=3.25 as=0.931626 ps=5.831927 w=3 l=0.5
X299 VDD1v8 SAR_validpin_0/AND2_1/Y SAR_validpin_0/DFFR_5/a_n420_n400# VDD1v8 sky130_fd_pr__pfet_01v8 ad=0.452887 pd=2.61211 as=0.8 ps=4.8 w=2 l=0.5
X300 SAR_validpin_0/DFFR_5/a_3210_n400# SAR_validpin_0/DFFR_5/a_2090_n400# SAR_validpin_0/DFFR_5/a_2600_n430# VSS sky130_fd_pr__nfet_01v8 ad=0.25 pd=2.25 as=0.8 ps=4.8 w=2 l=0.5
X301 VDD1v8 SAR_validpin_0/DFFR_5/a_2600_n430# SAR_validpin_0/DFFR_5/a_2550_720# VDD1v8 sky130_fd_pr__pfet_01v8 ad=0.452887 pd=2.61211 as=0.25 ps=2.25 w=2 l=0.5
X302 SAR_validpin_0/DFFR_6/a_2090_n400# SAR_validpin_0/DFFR_6/a_n50_n400# SAR_validpin_0/DFFR_6/a_450_n400# VDD1v8 sky130_fd_pr__pfet_01v8 ad=1.38 pd=7.08 as=1.2 ps=6.96 w=3 l=0.5
X303 VDD1v8 SAR_validpin_0/DFFR_6/a_2090_n400# SAR_validpin_0/DFFR_6/a_2600_n430# VDD1v8 sky130_fd_pr__pfet_01v8 ad=0.452887 pd=2.61211 as=0.8 ps=4.8 w=2 l=0.5
X304 VSS SAR_validpin_0/AND2_1/Y SAR_validpin_0/DFFR_6/a_n420_n400# VSS sky130_fd_pr__nfet_01v8 ad=0.310542 pd=1.943976 as=0.4 ps=2.8 w=1 l=0.5
X305 SAR_validpin_0/DFFR_6/a_2550_n400# SAR_validpin_0/DFFR_6/a_n50_n400# SAR_validpin_0/DFFR_6/a_2090_n400# VSS sky130_fd_pr__nfet_01v8 ad=0.125 pd=1.25 as=0.475 ps=2.45 w=1 l=0.5
X306 VSS SAR_validpin_0/DFFR_6/a_2600_n430# SAR_validpin_0/DFFR_6/a_2550_n400# VSS sky130_fd_pr__nfet_01v8 ad=0.310542 pd=1.943976 as=0.125 ps=1.25 w=1 l=0.5
X307 SAR_validpin_0/DFFR_6/a_1460_n400# SAR_validpin_0/DFFR_6/a_450_n400# SAR_validpin_0/DFFR_6/a_1310_n400# VSS sky130_fd_pr__nfet_01v8 ad=0.375 pd=3.25 as=0.375 ps=3.25 w=3 l=0.5
X308 SAR_validpin_0/DFFR_6/a_350_n430# SAR_validpin_0/DFFR_6/a_n420_n400# SAR_validpin_0/DFFR_6/a_1460_n400# VSS sky130_fd_pr__nfet_01v8 ad=1.2 pd=6.8 as=0.375 ps=3.25 w=3 l=0.5
X309 VSS RST_N SAR_validpin_0/DFFR_6/a_3210_n400# VSS sky130_fd_pr__nfet_01v8 ad=0.621084 pd=3.887952 as=0.25 ps=2.25 w=2 l=0.5
X310 SAR_validpin_0/DFFR_6/a_90_n400# SAR_validpin_0/AND2_1/Y SAR_validpin_0/DFFR_6/a_350_n430# VSS sky130_fd_pr__nfet_01v8 ad=1.425 pd=7.35 as=1.2 ps=6.8 w=3 l=0.5
X311 SAR_validpin_0/DFFR_6/a_n50_n400# SAR_validpin_0/AND2_0/Y VDD1v8 VDD1v8 sky130_fd_pr__pfet_01v8 ad=0.8 pd=4.8 as=0.452887 ps=2.61211 w=2 l=0.5
X312 SAR_validpin_0/DFFR_6/a_n50_n400# SAR_validpin_0/AND2_0/Y VSS VSS sky130_fd_pr__nfet_01v8 ad=0.4 pd=2.8 as=0.310542 ps=1.943976 w=1 l=0.5
X313 SAR_validpin_0/DFFR_6/a_2550_720# SAR_validpin_0/AND2_0/Y SAR_validpin_0/DFFR_6/a_2090_n400# VDD1v8 sky130_fd_pr__pfet_01v8 ad=0.25 pd=2.25 as=0.92 ps=4.72 w=2 l=0.5
X314 SAR_validpin_0/DFFR_6/a_350_n430# SAR_validpin_0/AND2_1/Y SAR_validpin_0/DFFR_6/a_1130_520# VDD1v8 sky130_fd_pr__pfet_01v8 ad=1.608572 pd=8.971429 as=1.066667 ps=5.866667 w=4 l=0.5
X315 SAR_validpin_0/DFFR_6/a_1130_520# SAR_validpin_0/DFFR_6/a_450_n400# VDD1v8 VDD1v8 sky130_fd_pr__pfet_01v8 ad=1.066667 pd=5.866667 as=0.905774 ps=5.224219 w=4 l=0.5
X316 ADC_OUT3 SAR_validpin_0/DFFR_6/a_2600_n430# VSS VSS sky130_fd_pr__nfet_01v8 ad=0.4 pd=2.8 as=0.310542 ps=1.943976 w=1 l=0.5
X317 ADC_OUT3 SAR_validpin_0/DFFR_6/a_2600_n430# VDD1v8 VDD1v8 sky130_fd_pr__pfet_01v8 ad=0.8 pd=4.8 as=0.452887 ps=2.61211 w=2 l=0.5
X318 SAR_validpin_0/DFFR_6/a_90_n400# SAR_validpin_0/DFFR_6/a_n420_n400# SAR_validpin_0/DFFR_6/a_350_n430# VDD1v8 sky130_fd_pr__pfet_01v8 ad=1.38 pd=7.08 as=1.206429 ps=6.728571 w=3 l=0.5
X319 SAR_validpin_0/DFFR_6/a_2600_n430# RST_N VDD1v8 VDD1v8 sky130_fd_pr__pfet_01v8 ad=0.8 pd=4.8 as=0.452887 ps=2.61211 w=2 l=0.5
X320 SAR_validpin_0/DFFR_6/a_450_n400# SAR_validpin_0/DFFR_6/a_350_n430# VDD1v8 VDD1v8 sky130_fd_pr__pfet_01v8 ad=0.8 pd=4.64 as=0.452887 ps=2.61211 w=2 l=0.5
X321 VDD1v8 RST_N SAR_validpin_0/DFFR_6/a_1130_520# VDD1v8 sky130_fd_pr__pfet_01v8 ad=0.905774 pd=5.224219 as=1.066667 ps=5.866667 w=4 l=0.5
X322 VSS SAR_validpin_0/OR2_2/A SAR_validpin_0/DFFR_6/a_90_n400# VSS sky130_fd_pr__nfet_01v8 ad=0.310542 pd=1.943976 as=0.475 ps=2.45 w=1 l=0.5
X323 SAR_validpin_0/DFFR_6/a_2090_n400# SAR_validpin_0/AND2_0/Y SAR_validpin_0/DFFR_6/a_450_n400# VSS sky130_fd_pr__nfet_01v8 ad=1.425 pd=7.35 as=1.2 ps=7.2 w=3 l=0.5
X324 VDD1v8 SAR_validpin_0/OR2_2/A SAR_validpin_0/DFFR_6/a_90_n400# VDD1v8 sky130_fd_pr__pfet_01v8 ad=0.452887 pd=2.61211 as=0.92 ps=4.72 w=2 l=0.5
X325 SAR_validpin_0/DFFR_6/a_450_n400# SAR_validpin_0/DFFR_6/a_350_n430# VSS VSS sky130_fd_pr__nfet_01v8 ad=0.4 pd=2.4 as=0.310542 ps=1.943976 w=1 l=0.5
X326 SAR_validpin_0/DFFR_6/a_1310_n400# RST_N VSS VSS sky130_fd_pr__nfet_01v8 ad=0.375 pd=3.25 as=0.931626 ps=5.831927 w=3 l=0.5
X327 VDD1v8 SAR_validpin_0/AND2_1/Y SAR_validpin_0/DFFR_6/a_n420_n400# VDD1v8 sky130_fd_pr__pfet_01v8 ad=0.452887 pd=2.61211 as=0.8 ps=4.8 w=2 l=0.5
X328 SAR_validpin_0/DFFR_6/a_3210_n400# SAR_validpin_0/DFFR_6/a_2090_n400# SAR_validpin_0/DFFR_6/a_2600_n430# VSS sky130_fd_pr__nfet_01v8 ad=0.25 pd=2.25 as=0.8 ps=4.8 w=2 l=0.5
X329 VDD1v8 SAR_validpin_0/DFFR_6/a_2600_n430# SAR_validpin_0/DFFR_6/a_2550_720# VDD1v8 sky130_fd_pr__pfet_01v8 ad=0.452887 pd=2.61211 as=0.25 ps=2.25 w=2 l=0.5
X330 SAR_validpin_0/DFFR_7/a_2090_n400# SAR_validpin_0/DFFR_7/a_n50_n400# SAR_validpin_0/DFFR_7/a_450_n400# VDD1v8 sky130_fd_pr__pfet_01v8 ad=1.38 pd=7.08 as=1.2 ps=6.96 w=3 l=0.5
X331 VDD1v8 SAR_validpin_0/DFFR_7/a_2090_n400# SAR_validpin_0/DFFR_7/a_2600_n430# VDD1v8 sky130_fd_pr__pfet_01v8 ad=0.452887 pd=2.61211 as=0.8 ps=4.8 w=2 l=0.5
X332 VSS SARclkgen_0/PHIB SAR_validpin_0/DFFR_7/a_n420_n400# VSS sky130_fd_pr__nfet_01v8 ad=0.310542 pd=1.943976 as=0.4 ps=2.8 w=1 l=0.5
X333 SAR_validpin_0/DFFR_7/a_2550_n400# SAR_validpin_0/DFFR_7/a_n50_n400# SAR_validpin_0/DFFR_7/a_2090_n400# VSS sky130_fd_pr__nfet_01v8 ad=0.125 pd=1.25 as=0.475 ps=2.45 w=1 l=0.5
X334 VSS SAR_validpin_0/DFFR_7/a_2600_n430# SAR_validpin_0/DFFR_7/a_2550_n400# VSS sky130_fd_pr__nfet_01v8 ad=0.310542 pd=1.943976 as=0.125 ps=1.25 w=1 l=0.5
X335 SAR_validpin_0/DFFR_7/a_1460_n400# SAR_validpin_0/DFFR_7/a_450_n400# SAR_validpin_0/DFFR_7/a_1310_n400# VSS sky130_fd_pr__nfet_01v8 ad=0.375 pd=3.25 as=0.375 ps=3.25 w=3 l=0.5
X336 SAR_validpin_0/DFFR_7/a_350_n430# SAR_validpin_0/DFFR_7/a_n420_n400# SAR_validpin_0/DFFR_7/a_1460_n400# VSS sky130_fd_pr__nfet_01v8 ad=1.2 pd=6.8 as=0.375 ps=3.25 w=3 l=0.5
X337 VSS RST_N SAR_validpin_0/DFFR_7/a_3210_n400# VSS sky130_fd_pr__nfet_01v8 ad=0.621084 pd=3.887952 as=0.25 ps=2.25 w=2 l=0.5
X338 SAR_validpin_0/DFFR_7/a_90_n400# SARclkgen_0/PHIB SAR_validpin_0/DFFR_7/a_350_n430# VSS sky130_fd_pr__nfet_01v8 ad=1.425 pd=7.35 as=1.2 ps=6.8 w=3 l=0.5
X339 SAR_validpin_0/DFFR_7/a_n50_n400# SARclkgen_0/PHIA VDD1v8 VDD1v8 sky130_fd_pr__pfet_01v8 ad=0.8 pd=4.8 as=0.452887 ps=2.61211 w=2 l=0.5
X340 SAR_validpin_0/DFFR_7/a_n50_n400# SARclkgen_0/PHIA VSS VSS sky130_fd_pr__nfet_01v8 ad=0.4 pd=2.8 as=0.310542 ps=1.943976 w=1 l=0.5
X341 SAR_validpin_0/DFFR_7/a_2550_720# SARclkgen_0/PHIA SAR_validpin_0/DFFR_7/a_2090_n400# VDD1v8 sky130_fd_pr__pfet_01v8 ad=0.25 pd=2.25 as=0.92 ps=4.72 w=2 l=0.5
X342 SAR_validpin_0/DFFR_7/a_350_n430# SARclkgen_0/PHIB SAR_validpin_0/DFFR_7/a_1130_520# VDD1v8 sky130_fd_pr__pfet_01v8 ad=1.608572 pd=8.971429 as=1.066667 ps=5.866667 w=4 l=0.5
X343 SAR_validpin_0/DFFR_7/a_1130_520# SAR_validpin_0/DFFR_7/a_450_n400# VDD1v8 VDD1v8 sky130_fd_pr__pfet_01v8 ad=1.066667 pd=5.866667 as=0.905774 ps=5.224219 w=4 l=0.5
X344 SAR_validpin_0/OR2_2/A SAR_validpin_0/DFFR_7/a_2600_n430# VSS VSS sky130_fd_pr__nfet_01v8 ad=0.4375 pd=2.425 as=0.310542 ps=1.943976 w=1 l=0.5
X345 SAR_validpin_0/OR2_2/A SAR_validpin_0/DFFR_7/a_2600_n430# VDD1v8 VDD1v8 sky130_fd_pr__pfet_01v8 ad=0.86 pd=4.68 as=0.452887 ps=2.61211 w=2 l=0.5
X346 SAR_validpin_0/DFFR_7/a_90_n400# SAR_validpin_0/DFFR_7/a_n420_n400# SAR_validpin_0/DFFR_7/a_350_n430# VDD1v8 sky130_fd_pr__pfet_01v8 ad=1.38 pd=7.08 as=1.206429 ps=6.728571 w=3 l=0.5
X347 SAR_validpin_0/DFFR_7/a_2600_n430# RST_N VDD1v8 VDD1v8 sky130_fd_pr__pfet_01v8 ad=0.8 pd=4.8 as=0.452887 ps=2.61211 w=2 l=0.5
X348 SAR_validpin_0/DFFR_7/a_450_n400# SAR_validpin_0/DFFR_7/a_350_n430# VDD1v8 VDD1v8 sky130_fd_pr__pfet_01v8 ad=0.8 pd=4.64 as=0.452887 ps=2.61211 w=2 l=0.5
X349 VDD1v8 RST_N SAR_validpin_0/DFFR_7/a_1130_520# VDD1v8 sky130_fd_pr__pfet_01v8 ad=0.905774 pd=5.224219 as=1.066667 ps=5.866667 w=4 l=0.5
X350 VSS SAR_validpin_0/DFFR_7/D SAR_validpin_0/DFFR_7/a_90_n400# VSS sky130_fd_pr__nfet_01v8 ad=0.310542 pd=1.943976 as=0.475 ps=2.45 w=1 l=0.5
X351 SAR_validpin_0/DFFR_7/a_2090_n400# SARclkgen_0/PHIA SAR_validpin_0/DFFR_7/a_450_n400# VSS sky130_fd_pr__nfet_01v8 ad=1.425 pd=7.35 as=1.2 ps=7.2 w=3 l=0.5
X352 VDD1v8 SAR_validpin_0/DFFR_7/D SAR_validpin_0/DFFR_7/a_90_n400# VDD1v8 sky130_fd_pr__pfet_01v8 ad=0.452887 pd=2.61211 as=0.92 ps=4.72 w=2 l=0.5
X353 SAR_validpin_0/DFFR_7/a_450_n400# SAR_validpin_0/DFFR_7/a_350_n430# VSS VSS sky130_fd_pr__nfet_01v8 ad=0.4 pd=2.4 as=0.310542 ps=1.943976 w=1 l=0.5
X354 SAR_validpin_0/DFFR_7/a_1310_n400# RST_N VSS VSS sky130_fd_pr__nfet_01v8 ad=0.375 pd=3.25 as=0.931626 ps=5.831927 w=3 l=0.5
X355 VDD1v8 SARclkgen_0/PHIB SAR_validpin_0/DFFR_7/a_n420_n400# VDD1v8 sky130_fd_pr__pfet_01v8 ad=0.452887 pd=2.61211 as=0.8 ps=4.8 w=2 l=0.5
X356 SAR_validpin_0/DFFR_7/a_3210_n400# SAR_validpin_0/DFFR_7/a_2090_n400# SAR_validpin_0/DFFR_7/a_2600_n430# VSS sky130_fd_pr__nfet_01v8 ad=0.25 pd=2.25 as=0.8 ps=4.8 w=2 l=0.5
X357 VDD1v8 SAR_validpin_0/DFFR_7/a_2600_n430# SAR_validpin_0/DFFR_7/a_2550_720# VDD1v8 sky130_fd_pr__pfet_01v8 ad=0.452887 pd=2.61211 as=0.25 ps=2.25 w=2 l=0.5
X358 SAR_validpin_0/AND2_0/a_90_n200# shift1v8to5_1/A VSS VSS sky130_fd_pr__nfet_01v8 ad=0.25 pd=2.25 as=0.621084 ps=3.887952 w=2 l=0.5
X359 SAR_validpin_0/AND2_0/a_n100_1100# SARclkgen_0/PHIA SAR_validpin_0/AND2_0/a_90_n200# VSS sky130_fd_pr__nfet_01v8 ad=0.8 pd=4.8 as=0.25 ps=2.25 w=2 l=0.5
X360 SAR_validpin_0/AND2_0/Y SAR_validpin_0/AND2_0/a_n100_1100# VSS VSS sky130_fd_pr__nfet_01v8 ad=0.4 pd=2.8 as=0.310542 ps=1.943976 w=1 l=0.5
X361 VDD1v8 shift1v8to5_1/A SAR_validpin_0/AND2_0/a_n100_1100# VDD1v8 sky130_fd_pr__pfet_01v8 ad=0.452887 pd=2.61211 as=0.9 ps=4.9 w=2 l=0.5
X362 SAR_validpin_0/AND2_0/a_n100_1100# SARclkgen_0/PHIA VDD1v8 VDD1v8 sky130_fd_pr__pfet_01v8 ad=0.9 pd=4.9 as=0.452887 ps=2.61211 w=2 l=0.5
X363 SAR_validpin_0/AND2_0/Y SAR_validpin_0/AND2_0/a_n100_1100# VDD1v8 VDD1v8 sky130_fd_pr__pfet_01v8 ad=0.804 pd=4.82 as=0.455151 ps=2.62517 w=2.01 l=0.5
X364 SAR_validpin_0/DFFR_8/a_2090_n400# SAR_validpin_0/DFFR_8/a_n50_n400# SAR_validpin_0/DFFR_8/a_450_n400# VDD1v8 sky130_fd_pr__pfet_01v8 ad=1.38 pd=7.08 as=1.2 ps=6.96 w=3 l=0.5
X365 VDD1v8 SAR_validpin_0/DFFR_8/a_2090_n400# SAR_validpin_0/DFFR_8/a_2600_n430# VDD1v8 sky130_fd_pr__pfet_01v8 ad=0.452887 pd=2.61211 as=0.8 ps=4.8 w=2 l=0.5
X366 VSS SARclkgen_0/PHIB SAR_validpin_0/DFFR_8/a_n420_n400# VSS sky130_fd_pr__nfet_01v8 ad=0.310542 pd=1.943976 as=0.4 ps=2.8 w=1 l=0.5
X367 SAR_validpin_0/DFFR_8/a_2550_n400# SAR_validpin_0/DFFR_8/a_n50_n400# SAR_validpin_0/DFFR_8/a_2090_n400# VSS sky130_fd_pr__nfet_01v8 ad=0.125 pd=1.25 as=0.475 ps=2.45 w=1 l=0.5
X368 VSS SAR_validpin_0/DFFR_8/a_2600_n430# SAR_validpin_0/DFFR_8/a_2550_n400# VSS sky130_fd_pr__nfet_01v8 ad=0.310542 pd=1.943976 as=0.125 ps=1.25 w=1 l=0.5
X369 SAR_validpin_0/DFFR_8/a_1460_n400# SAR_validpin_0/DFFR_8/a_450_n400# SAR_validpin_0/DFFR_8/a_1310_n400# VSS sky130_fd_pr__nfet_01v8 ad=0.375 pd=3.25 as=0.375 ps=3.25 w=3 l=0.5
X370 SAR_validpin_0/DFFR_8/a_350_n430# SAR_validpin_0/DFFR_8/a_n420_n400# SAR_validpin_0/DFFR_8/a_1460_n400# VSS sky130_fd_pr__nfet_01v8 ad=1.2 pd=6.8 as=0.375 ps=3.25 w=3 l=0.5
X371 VSS RST_N SAR_validpin_0/DFFR_8/a_3210_n400# VSS sky130_fd_pr__nfet_01v8 ad=0.621084 pd=3.887952 as=0.25 ps=2.25 w=2 l=0.5
X372 SAR_validpin_0/DFFR_8/a_90_n400# SARclkgen_0/PHIB SAR_validpin_0/DFFR_8/a_350_n430# VSS sky130_fd_pr__nfet_01v8 ad=1.425 pd=7.35 as=1.2 ps=6.8 w=3 l=0.5
X373 SAR_validpin_0/DFFR_8/a_n50_n400# SARclkgen_0/PHIA VDD1v8 VDD1v8 sky130_fd_pr__pfet_01v8 ad=0.8 pd=4.8 as=0.452887 ps=2.61211 w=2 l=0.5
X374 SAR_validpin_0/DFFR_8/a_n50_n400# SARclkgen_0/PHIA VSS VSS sky130_fd_pr__nfet_01v8 ad=0.4 pd=2.8 as=0.310542 ps=1.943976 w=1 l=0.5
X375 SAR_validpin_0/DFFR_8/a_2550_720# SARclkgen_0/PHIA SAR_validpin_0/DFFR_8/a_2090_n400# VDD1v8 sky130_fd_pr__pfet_01v8 ad=0.25 pd=2.25 as=0.92 ps=4.72 w=2 l=0.5
X376 SAR_validpin_0/DFFR_8/a_350_n430# SARclkgen_0/PHIB SAR_validpin_0/DFFR_8/a_1130_520# VDD1v8 sky130_fd_pr__pfet_01v8 ad=1.608572 pd=8.971429 as=1.066667 ps=5.866667 w=4 l=0.5
X377 SAR_validpin_0/DFFR_8/a_1130_520# SAR_validpin_0/DFFR_8/a_450_n400# VDD1v8 VDD1v8 sky130_fd_pr__pfet_01v8 ad=1.066667 pd=5.866667 as=0.905774 ps=5.224219 w=4 l=0.5
X378 VALID SAR_validpin_0/DFFR_8/a_2600_n430# VSS VSS sky130_fd_pr__nfet_01v8 ad=0.4 pd=2.8 as=0.310542 ps=1.943976 w=1 l=0.5
X379 VALID SAR_validpin_0/DFFR_8/a_2600_n430# VDD1v8 VDD1v8 sky130_fd_pr__pfet_01v8 ad=0.8 pd=4.8 as=0.452887 ps=2.61211 w=2 l=0.5
X380 SAR_validpin_0/DFFR_8/a_90_n400# SAR_validpin_0/DFFR_8/a_n420_n400# SAR_validpin_0/DFFR_8/a_350_n430# VDD1v8 sky130_fd_pr__pfet_01v8 ad=1.38 pd=7.08 as=1.206429 ps=6.728571 w=3 l=0.5
X381 SAR_validpin_0/DFFR_8/a_2600_n430# RST_N VDD1v8 VDD1v8 sky130_fd_pr__pfet_01v8 ad=0.8 pd=4.8 as=0.452887 ps=2.61211 w=2 l=0.5
X382 SAR_validpin_0/DFFR_8/a_450_n400# SAR_validpin_0/DFFR_8/a_350_n430# VDD1v8 VDD1v8 sky130_fd_pr__pfet_01v8 ad=0.8 pd=4.64 as=0.452887 ps=2.61211 w=2 l=0.5
X383 VDD1v8 RST_N SAR_validpin_0/DFFR_8/a_1130_520# VDD1v8 sky130_fd_pr__pfet_01v8 ad=0.905774 pd=5.224219 as=1.066667 ps=5.866667 w=4 l=0.5
X384 VSS shift1v8to5_1/A SAR_validpin_0/DFFR_8/a_90_n400# VSS sky130_fd_pr__nfet_01v8 ad=0.310542 pd=1.943976 as=0.475 ps=2.45 w=1 l=0.5
X385 SAR_validpin_0/DFFR_8/a_2090_n400# SARclkgen_0/PHIA SAR_validpin_0/DFFR_8/a_450_n400# VSS sky130_fd_pr__nfet_01v8 ad=1.425 pd=7.35 as=1.2 ps=7.2 w=3 l=0.5
X386 VDD1v8 shift1v8to5_1/A SAR_validpin_0/DFFR_8/a_90_n400# VDD1v8 sky130_fd_pr__pfet_01v8 ad=0.452887 pd=2.61211 as=0.92 ps=4.72 w=2 l=0.5
X387 SAR_validpin_0/DFFR_8/a_450_n400# SAR_validpin_0/DFFR_8/a_350_n430# VSS VSS sky130_fd_pr__nfet_01v8 ad=0.4 pd=2.4 as=0.310542 ps=1.943976 w=1 l=0.5
X388 SAR_validpin_0/DFFR_8/a_1310_n400# RST_N VSS VSS sky130_fd_pr__nfet_01v8 ad=0.375 pd=3.25 as=0.931626 ps=5.831927 w=3 l=0.5
X389 VDD1v8 SARclkgen_0/PHIB SAR_validpin_0/DFFR_8/a_n420_n400# VDD1v8 sky130_fd_pr__pfet_01v8 ad=0.452887 pd=2.61211 as=0.8 ps=4.8 w=2 l=0.5
X390 SAR_validpin_0/DFFR_8/a_3210_n400# SAR_validpin_0/DFFR_8/a_2090_n400# SAR_validpin_0/DFFR_8/a_2600_n430# VSS sky130_fd_pr__nfet_01v8 ad=0.25 pd=2.25 as=0.8 ps=4.8 w=2 l=0.5
X391 VDD1v8 SAR_validpin_0/DFFR_8/a_2600_n430# SAR_validpin_0/DFFR_8/a_2550_720# VDD1v8 sky130_fd_pr__pfet_01v8 ad=0.452887 pd=2.61211 as=0.25 ps=2.25 w=2 l=0.5
X392 SAR_validpin_0/AND2_1/a_90_n200# shift1v8to5_1/A VSS VSS sky130_fd_pr__nfet_01v8 ad=0.25 pd=2.25 as=0.621084 ps=3.887952 w=2 l=0.5
X393 SAR_validpin_0/AND2_1/a_n100_1100# SARclkgen_0/PHIB SAR_validpin_0/AND2_1/a_90_n200# VSS sky130_fd_pr__nfet_01v8 ad=0.8 pd=4.8 as=0.25 ps=2.25 w=2 l=0.5
X394 SAR_validpin_0/AND2_1/Y SAR_validpin_0/AND2_1/a_n100_1100# VSS VSS sky130_fd_pr__nfet_01v8 ad=0.4 pd=2.8 as=0.310542 ps=1.943976 w=1 l=0.5
X395 VDD1v8 shift1v8to5_1/A SAR_validpin_0/AND2_1/a_n100_1100# VDD1v8 sky130_fd_pr__pfet_01v8 ad=0.452887 pd=2.61211 as=0.9 ps=4.9 w=2 l=0.5
X396 SAR_validpin_0/AND2_1/a_n100_1100# SARclkgen_0/PHIB VDD1v8 VDD1v8 sky130_fd_pr__pfet_01v8 ad=0.9 pd=4.9 as=0.452887 ps=2.61211 w=2 l=0.5
X397 SAR_validpin_0/AND2_1/Y SAR_validpin_0/AND2_1/a_n100_1100# VDD1v8 VDD1v8 sky130_fd_pr__pfet_01v8 ad=0.804 pd=4.82 as=0.455151 ps=2.62517 w=2.01 l=0.5
X398 SAR_validpin_0/AND2_2/a_90_n200# shift5to1v8_0/Y VSS VSS sky130_fd_pr__nfet_01v8 ad=0.25 pd=2.25 as=0.621084 ps=3.887952 w=2 l=0.5
X399 SAR_validpin_0/AND2_2/a_n100_1100# shift1v8to5_1/A SAR_validpin_0/AND2_2/a_90_n200# VSS sky130_fd_pr__nfet_01v8 ad=0.8 pd=4.8 as=0.25 ps=2.25 w=2 l=0.5
X400 SAR_validpin_0/DFFR_3/D SAR_validpin_0/AND2_2/a_n100_1100# VSS VSS sky130_fd_pr__nfet_01v8 ad=0.4 pd=2.8 as=0.310542 ps=1.943976 w=1 l=0.5
X401 VDD1v8 shift5to1v8_0/Y SAR_validpin_0/AND2_2/a_n100_1100# VDD1v8 sky130_fd_pr__pfet_01v8 ad=0.452887 pd=2.61211 as=0.9 ps=4.9 w=2 l=0.5
X402 SAR_validpin_0/AND2_2/a_n100_1100# shift1v8to5_1/A VDD1v8 VDD1v8 sky130_fd_pr__pfet_01v8 ad=0.9 pd=4.9 as=0.452887 ps=2.61211 w=2 l=0.5
X403 SAR_validpin_0/DFFR_3/D SAR_validpin_0/AND2_2/a_n100_1100# VDD1v8 VDD1v8 sky130_fd_pr__pfet_01v8 ad=0.804 pd=4.82 as=0.455151 ps=2.62517 w=2.01 l=0.5
X404 SAR_validpin_0/DFFS_0/a_2090_n400# SAR_validpin_0/DFFS_0/a_n50_n400# SAR_validpin_0/DFFS_0/a_350_n430# VDD1v8 sky130_fd_pr__pfet_01v8 ad=1.328571 pd=7.114286 as=1.2 ps=6.685714 w=3 l=0.5
X405 VDD1v8 SAR_validpin_0/DFFS_0/a_600_n400# SAR_validpin_0/DFFS_0/a_2090_n400# VDD1v8 sky130_fd_pr__pfet_01v8 ad=0.452887 pd=2.61211 as=0.885714 ps=4.742857 w=2 l=0.5
X406 VSS SARclkgen_0/PHIB SAR_validpin_0/DFFS_0/a_n420_n400# VSS sky130_fd_pr__nfet_01v8 ad=0.310542 pd=1.943976 as=0.4 ps=2.8 w=1 l=0.5
X407 SAR_validpin_0/DFFS_0/a_2550_n400# SAR_validpin_0/DFFS_0/a_n420_n400# SAR_validpin_0/DFFS_0/a_600_n400# VSS sky130_fd_pr__nfet_01v8 ad=0.125 pd=1.25 as=0.4 ps=2.4 w=1 l=0.5
X408 VSS SAR_validpin_0/DFFS_0/a_2090_n400# SAR_validpin_0/DFFS_0/a_2550_n400# VSS sky130_fd_pr__nfet_01v8 ad=0.310542 pd=1.943976 as=0.125 ps=1.25 w=1 l=0.5
X409 SAR_validpin_0/DFFS_0/a_1460_n400# SAR_validpin_0/DFFS_0/a_450_n400# SAR_validpin_0/DFFS_0/a_1310_n400# VSS sky130_fd_pr__nfet_01v8 ad=0.375 pd=3.25 as=0.375 ps=3.25 w=3 l=0.5
X410 SAR_validpin_0/DFFS_0/a_350_n430# SAR_validpin_0/DFFS_0/a_n50_n400# SAR_validpin_0/DFFS_0/a_1460_n400# VSS sky130_fd_pr__nfet_01v8 ad=1.2 pd=6.8 as=0.375 ps=3.25 w=3 l=0.5
X411 VSS RST_N SAR_validpin_0/DFFS_0/a_3210_n400# VSS sky130_fd_pr__nfet_01v8 ad=0.621084 pd=3.887952 as=0.25 ps=2.25 w=2 l=0.5
X412 SAR_validpin_0/DFFS_0/a_90_n400# SARclkgen_0/PHIB SAR_validpin_0/DFFS_0/a_600_n400# VSS sky130_fd_pr__nfet_01v8 ad=1.425 pd=7.35 as=1.2 ps=7.2 w=3 l=0.5
X413 SAR_validpin_0/DFFS_0/a_n50_n400# SARclkgen_0/PHIA VDD1v8 VDD1v8 sky130_fd_pr__pfet_01v8 ad=0.8 pd=4.8 as=0.452887 ps=2.61211 w=2 l=0.5
X414 SAR_validpin_0/DFFS_0/a_n50_n400# SARclkgen_0/PHIA VSS VSS sky130_fd_pr__nfet_01v8 ad=0.4 pd=2.8 as=0.310542 ps=1.943976 w=1 l=0.5
X415 SAR_validpin_0/DFFS_0/a_2550_720# SARclkgen_0/PHIB SAR_validpin_0/DFFS_0/a_600_n400# VDD1v8 sky130_fd_pr__pfet_01v8 ad=0.25 pd=2.25 as=0.8 ps=4.64 w=2 l=0.5
X416 SAR_validpin_0/DFFS_0/a_350_n430# SARclkgen_0/PHIA SAR_validpin_0/DFFS_0/a_1130_520# VDD1v8 sky130_fd_pr__pfet_01v8 ad=1.6 pd=8.914286 as=1.066667 ps=5.866667 w=4 l=0.5
X417 SAR_validpin_0/DFFS_0/a_1130_520# SAR_validpin_0/DFFS_0/a_450_n400# VDD1v8 VDD1v8 sky130_fd_pr__pfet_01v8 ad=1.066667 pd=5.866667 as=0.905774 ps=5.224219 w=4 l=0.5
X418 SAR_validpin_0/OR2_2/B SAR_validpin_0/DFFS_0/a_450_n400# VSS VSS sky130_fd_pr__nfet_01v8 ad=0.4 pd=2.8 as=0.310542 ps=1.943976 w=1 l=0.5
X419 SAR_validpin_0/OR2_2/B SAR_validpin_0/DFFS_0/a_450_n400# VDD1v8 VDD1v8 sky130_fd_pr__pfet_01v8 ad=0.8 pd=4.8 as=0.452887 ps=2.61211 w=2 l=0.5
X420 SAR_validpin_0/DFFS_0/a_90_n400# SAR_validpin_0/DFFS_0/a_n420_n400# SAR_validpin_0/DFFS_0/a_600_n400# VDD1v8 sky130_fd_pr__pfet_01v8 ad=1.38 pd=7.08 as=1.2 ps=6.96 w=3 l=0.5
X421 SAR_validpin_0/DFFS_0/a_2090_n400# RST_N VDD1v8 VDD1v8 sky130_fd_pr__pfet_01v8 ad=0.885714 pd=4.742857 as=0.452887 ps=2.61211 w=2 l=0.5
X422 SAR_validpin_0/DFFS_0/a_450_n400# SAR_validpin_0/DFFS_0/a_350_n430# VDD1v8 VDD1v8 sky130_fd_pr__pfet_01v8 ad=0.8 pd=4.8 as=0.452887 ps=2.61211 w=2 l=0.5
X423 VDD1v8 RST_N SAR_validpin_0/DFFS_0/a_1130_520# VDD1v8 sky130_fd_pr__pfet_01v8 ad=0.905774 pd=5.224219 as=1.066667 ps=5.866667 w=4 l=0.5
X424 VSS shift1v8to5_1/A SAR_validpin_0/DFFS_0/a_90_n400# VSS sky130_fd_pr__nfet_01v8 ad=0.310542 pd=1.943976 as=0.475 ps=2.45 w=1 l=0.5
X425 SAR_validpin_0/DFFS_0/a_2090_n400# SARclkgen_0/PHIA SAR_validpin_0/DFFS_0/a_350_n430# VSS sky130_fd_pr__nfet_01v8 ad=1.38 pd=7.08 as=1.2 ps=6.8 w=3 l=0.5
X426 VDD1v8 shift1v8to5_1/A SAR_validpin_0/DFFS_0/a_90_n400# VDD1v8 sky130_fd_pr__pfet_01v8 ad=0.452887 pd=2.61211 as=0.92 ps=4.72 w=2 l=0.5
X427 SAR_validpin_0/DFFS_0/a_450_n400# SAR_validpin_0/DFFS_0/a_350_n430# VSS VSS sky130_fd_pr__nfet_01v8 ad=0.4 pd=2.8 as=0.310542 ps=1.943976 w=1 l=0.5
X428 SAR_validpin_0/DFFS_0/a_1310_n400# RST_N VSS VSS sky130_fd_pr__nfet_01v8 ad=0.375 pd=3.25 as=0.931626 ps=5.831927 w=3 l=0.5
X429 VDD1v8 SARclkgen_0/PHIB SAR_validpin_0/DFFS_0/a_n420_n400# VDD1v8 sky130_fd_pr__pfet_01v8 ad=0.452887 pd=2.61211 as=0.8 ps=4.8 w=2 l=0.5
X430 SAR_validpin_0/DFFS_0/a_3210_n400# SAR_validpin_0/DFFS_0/a_600_n400# SAR_validpin_0/DFFS_0/a_2090_n400# VSS sky130_fd_pr__nfet_01v8 ad=0.25 pd=2.25 as=0.92 ps=4.72 w=2 l=0.5
X431 VDD1v8 SAR_validpin_0/DFFS_0/a_2090_n400# SAR_validpin_0/DFFS_0/a_2550_720# VDD1v8 sky130_fd_pr__pfet_01v8 ad=0.452887 pd=2.61211 as=0.25 ps=2.25 w=2 l=0.5
X432 shift1v8to5_4/5v_pfet_1_2_2/D CLK_comp VSS VSS sky130_fd_pr__nfet_g5v0d10v5 ad=18 pd=18 as=16.25 ps=18.375 w=6 l=1
X433 strongarm_0/clk shift1v8to5_4/5v_pfet_1_2_0/D VSS VSS sky130_fd_pr__nfet_g5v0d10v5 ad=18 pd=18 as=16.25 ps=18.375 w=6 l=1
X434 shift1v8to5_4/5v_pfet_1_2_0/D CLK_comp VDD1v8 VDD1v8 sky130_fd_pr__pfet_g5v0d10v5 ad=2 pd=6 as=2 ps=6 w=2 l=1
X435 strongarm_0/clk shift1v8to5_4/5v_pfet_1_2_2/D VDD_5V VDD_5V sky130_fd_pr__pfet_g5v0d10v5 ad=2 pd=6 as=2 ps=6.190476 w=2 l=1
X436 shift1v8to5_4/5v_pfet_1_2_2/D strongarm_0/clk VDD_5V VDD_5V sky130_fd_pr__pfet_g5v0d10v5 ad=2 pd=6 as=2 ps=6.190476 w=2 l=1
X437 shift1v8to5_4/5v_pfet_1_2_0/D CLK_comp VSS VSS sky130_fd_pr__nfet_g5v0d10v5 ad=1 pd=4 as=2.708333 ps=3.0625 w=1 l=1
X438 shift5to1v8_0/5v_pfet_1_2_1/G SRLatch5V_0/NQ VDD1v8 VDD1v8 sky130_fd_pr__pfet_g5v0d10v5 ad=2 pd=6 as=2 ps=6 w=2 l=1
X439 shift5to1v8_0/Y shift5to1v8_0/5v_pfet_1_2_1/G VDD1v8 VDD1v8 sky130_fd_pr__pfet_g5v0d10v5 ad=2 pd=6 as=2 ps=6 w=2 l=1
X440 shift5to1v8_0/5v_pfet_1_2_1/G SRLatch5V_0/NQ VSS VSS sky130_fd_pr__nfet_g5v0d10v5 ad=1 pd=4 as=2.708333 ps=3.0625 w=1 l=1
X441 shift5to1v8_0/Y shift5to1v8_0/5v_pfet_1_2_1/G VSS VSS sky130_fd_pr__nfet_g5v0d10v5 ad=1 pd=4 as=2.708333 ps=3.0625 w=1 l=1
X442 shift1v8to5_5/5v_pfet_1_2_2/D CLK VSS VSS sky130_fd_pr__nfet_g5v0d10v5 ad=18 pd=18 as=16.25 ps=18.375 w=6 l=1
X443 CLK5 shift1v8to5_5/5v_pfet_1_2_0/D VSS VSS sky130_fd_pr__nfet_g5v0d10v5 ad=18 pd=18 as=16.25 ps=18.375 w=6 l=1
X444 shift1v8to5_5/5v_pfet_1_2_0/D CLK VDD1v8 VDD1v8 sky130_fd_pr__pfet_g5v0d10v5 ad=2 pd=6 as=2 ps=6 w=2 l=1
X445 CLK5 shift1v8to5_5/5v_pfet_1_2_2/D VDD_5V VDD_5V sky130_fd_pr__pfet_g5v0d10v5 ad=2 pd=6 as=2 ps=6.190476 w=2 l=1
X446 shift1v8to5_5/5v_pfet_1_2_2/D CLK5 VDD_5V VDD_5V sky130_fd_pr__pfet_g5v0d10v5 ad=2 pd=6 as=2 ps=6.190476 w=2 l=1
X447 shift1v8to5_5/5v_pfet_1_2_0/D CLK VSS VSS sky130_fd_pr__nfet_g5v0d10v5 ad=1 pd=4 as=2.708333 ps=3.0625 w=1 l=1
X448 SRLatch5V_0/R strongarm_0/clk VDD_5V VDD_5V sky130_fd_pr__pfet_g5v0d10v5 ad=1 pd=3.333333 as=1 ps=3.095238 w=1 l=1
X449 strongarm_0/5v_pfet_1_1_0/D strongarm_0/clk VDD_5V VDD_5V sky130_fd_pr__pfet_g5v0d10v5 ad=1 pd=4 as=1 ps=3.095238 w=1 l=1
X450 SRLatch5V_0/S strongarm_0/clk VDD_5V VDD_5V sky130_fd_pr__pfet_g5v0d10v5 ad=1 pd=3.333333 as=1 ps=3.095238 w=1 l=1
X451 strongarm_0/5v_pfet_1_1_3/D strongarm_0/clk VDD_5V VDD_5V sky130_fd_pr__pfet_g5v0d10v5 ad=1 pd=4 as=1 ps=3.095238 w=1 l=1
X452 SRLatch5V_0/R SRLatch5V_0/S VDD_5V VDD_5V sky130_fd_pr__pfet_g5v0d10v5 ad=2 pd=6.666667 as=2 ps=6.190476 w=2 l=1
X453 SRLatch5V_0/S SRLatch5V_0/R VDD_5V VDD_5V sky130_fd_pr__pfet_g5v0d10v5 ad=2 pd=6.666667 as=2 ps=6.190476 w=2 l=1
X454 SRLatch5V_0/R SRLatch5V_0/S strongarm_0/5v_pfet_1_1_0/D VSS sky130_fd_pr__nfet_g5v0d10v5 ad=1 pd=4 as=1 ps=4 w=1 l=1
X455 strongarm_0/5v_nfet_1_1_3/S strongarm_0/clk VSS VSS sky130_fd_pr__nfet_g5v0d10v5 ad=1 pd=4 as=2.708333 ps=3.0625 w=1 l=1
X456 strongarm_0/5v_pfet_1_1_0/D CDAC_0/Vcm strongarm_0/5v_nfet_1_1_3/S VSS sky130_fd_pr__nfet_g5v0d10v5 ad=1 pd=4 as=1 ps=4 w=1 l=1
X457 strongarm_0/5v_pfet_1_1_3/D CDAC_0/Vout strongarm_0/5v_nfet_1_1_3/S VSS sky130_fd_pr__nfet_g5v0d10v5 ad=1 pd=4 as=1 ps=4 w=1 l=1
X458 SRLatch5V_0/S SRLatch5V_0/R strongarm_0/5v_pfet_1_1_3/D VSS sky130_fd_pr__nfet_g5v0d10v5 ad=1 pd=4 as=1 ps=4 w=1 l=1
X459 SARclkgen_0/AND2_1/B SARclkgen_0/PHIB VSS VSS sky130_fd_pr__nfet_01v8 ad=0.4 pd=2.8 as=0.310542 ps=1.943976 w=1 l=0.5
X460 SARclkgen_0/AND2_1/B SARclkgen_0/PHIB VDD1v8 VDD1v8 sky130_fd_pr__pfet_01v8 ad=0.804 pd=4.82 as=0.455151 ps=2.62517 w=2.01 l=0.5
X461 SARclkgen_0/AND2_0/B SARclkgen_0/PHIA VSS VSS sky130_fd_pr__nfet_01v8 ad=0.4 pd=2.8 as=0.310542 ps=1.943976 w=1 l=0.5
X462 SARclkgen_0/AND2_0/B SARclkgen_0/PHIA VDD1v8 VDD1v8 sky130_fd_pr__pfet_01v8 ad=0.804 pd=4.82 as=0.455151 ps=2.62517 w=2.01 l=0.5
X463 SARclkgen_0/AND2_0/A CLK VSS VSS sky130_fd_pr__nfet_01v8 ad=0.4 pd=2.8 as=0.310542 ps=1.943976 w=1 l=0.5
X464 SARclkgen_0/AND2_0/A CLK VDD1v8 VDD1v8 sky130_fd_pr__pfet_01v8 ad=0.804 pd=4.82 as=0.455151 ps=2.62517 w=2.01 l=0.5
X465 SARclkgen_0/AND2_0/a_90_n200# SARclkgen_0/AND2_0/B VSS VSS sky130_fd_pr__nfet_01v8 ad=0.25 pd=2.25 as=0.621084 ps=3.887952 w=2 l=0.5
X466 SARclkgen_0/AND2_0/a_n100_1100# SARclkgen_0/AND2_0/A SARclkgen_0/AND2_0/a_90_n200# VSS sky130_fd_pr__nfet_01v8 ad=0.8 pd=4.8 as=0.25 ps=2.25 w=2 l=0.5
X467 SARclkgen_0/PHIB SARclkgen_0/AND2_0/a_n100_1100# VSS VSS sky130_fd_pr__nfet_01v8 ad=0.4 pd=2.8 as=0.310542 ps=1.943976 w=1 l=0.5
X468 VDD1v8 SARclkgen_0/AND2_0/B SARclkgen_0/AND2_0/a_n100_1100# VDD1v8 sky130_fd_pr__pfet_01v8 ad=0.452887 pd=2.61211 as=0.9 ps=4.9 w=2 l=0.5
X469 SARclkgen_0/AND2_0/a_n100_1100# SARclkgen_0/AND2_0/A VDD1v8 VDD1v8 sky130_fd_pr__pfet_01v8 ad=0.9 pd=4.9 as=0.452887 ps=2.61211 w=2 l=0.5
X470 SARclkgen_0/PHIB SARclkgen_0/AND2_0/a_n100_1100# VDD1v8 VDD1v8 sky130_fd_pr__pfet_01v8 ad=0.804 pd=4.82 as=0.455151 ps=2.62517 w=2.01 l=0.5
X471 SARclkgen_0/AND2_1/a_90_n200# SARclkgen_0/AND2_1/B VSS VSS sky130_fd_pr__nfet_01v8 ad=0.25 pd=2.25 as=0.621084 ps=3.887952 w=2 l=0.5
X472 SARclkgen_0/AND2_1/a_n100_1100# CLK SARclkgen_0/AND2_1/a_90_n200# VSS sky130_fd_pr__nfet_01v8 ad=0.8 pd=4.8 as=0.25 ps=2.25 w=2 l=0.5
X473 SARclkgen_0/PHIA SARclkgen_0/AND2_1/a_n100_1100# VSS VSS sky130_fd_pr__nfet_01v8 ad=0.4 pd=2.8 as=0.310542 ps=1.943976 w=1 l=0.5
X474 VDD1v8 SARclkgen_0/AND2_1/B SARclkgen_0/AND2_1/a_n100_1100# VDD1v8 sky130_fd_pr__pfet_01v8 ad=0.452887 pd=2.61211 as=0.9 ps=4.9 w=2 l=0.5
X475 SARclkgen_0/AND2_1/a_n100_1100# CLK VDD1v8 VDD1v8 sky130_fd_pr__pfet_01v8 ad=0.9 pd=4.9 as=0.452887 ps=2.61211 w=2 l=0.5
X476 SARclkgen_0/PHIA SARclkgen_0/AND2_1/a_n100_1100# VDD1v8 VDD1v8 sky130_fd_pr__pfet_01v8 ad=0.804 pd=4.82 as=0.455151 ps=2.62517 w=2.01 l=0.5
X477 CDAC_0/SPDT_4/out NOT5V_0/Y VSS VDD_5V sky130_fd_pr__pfet_g5v0d10v5 ad=30 pd=26 as=207.625 ps=515.9 w=10 l=1
X478 VSS CLK5 CDAC_0/SPDT_4/out VSS sky130_fd_pr__nfet_g5v0d10v5 ad=27.083332 pd=30.625 as=30 ps=26 w=10 l=1
X479 CDAC_0/SPDT_4/out CLK5 Vin VDD_5V sky130_fd_pr__pfet_g5v0d10v5 ad=30 pd=26 as=30 ps=26 w=10 l=1
X480 Vin NOT5V_0/Y CDAC_0/SPDT_4/out VSS sky130_fd_pr__nfet_g5v0d10v5 ad=30 pd=26 as=30 ps=26 w=10 l=1
X481 CDAC_0/SPDT_3/out NOT5V_0/Y CDAC_0/b0 VDD_5V sky130_fd_pr__pfet_g5v0d10v5 ad=30 pd=26 as=26.666666 ps=26.666666 w=10 l=1
X482 CDAC_0/b0 CLK5 CDAC_0/SPDT_3/out VSS sky130_fd_pr__nfet_g5v0d10v5 ad=30 pd=27.5 as=30 ps=26 w=10 l=1
X483 CDAC_0/SPDT_3/out CLK5 Vin VDD_5V sky130_fd_pr__pfet_g5v0d10v5 ad=30 pd=26 as=30 ps=26 w=10 l=1
X484 Vin NOT5V_0/Y CDAC_0/SPDT_3/out VSS sky130_fd_pr__nfet_g5v0d10v5 ad=30 pd=26 as=30 ps=26 w=10 l=1
X485 CDAC_0/SPDT_2/out CDAC_0/Vout sky130_fd_pr__cap_mim_m3_1 l=5 w=10
X486 CDAC_0/SPDT_0/out CDAC_0/Vout sky130_fd_pr__cap_mim_m3_1 l=10 w=20
X487 CDAC_0/SPDT_1/out CDAC_0/Vout sky130_fd_pr__cap_mim_m3_1 l=10 w=10
X488 CDAC_0/Vcm CLK5 CDAC_0/Vout VDD_5V sky130_fd_pr__pfet_g5v0d10v5 ad=30 pd=26 as=30 ps=26 w=10 l=1
X489 CDAC_0/Vout NOT5V_0/Y CDAC_0/Vcm VSS sky130_fd_pr__nfet_g5v0d10v5 ad=30 pd=26 as=30 ps=26 w=10 l=1
X490 CDAC_0/SPDT_3/out CDAC_0/Vout sky130_fd_pr__cap_mim_m3_1 l=5 w=5
X491 CDAC_0/SPDT_4/out CDAC_0/Vout sky130_fd_pr__cap_mim_m3_1 l=5 w=5
X492 CDAC_0/SPDT_0/out NOT5V_0/Y CDAC_0/b3 VDD_5V sky130_fd_pr__pfet_g5v0d10v5 ad=30 pd=26 as=26.666666 ps=26.666666 w=10 l=1
X493 CDAC_0/b3 CLK5 CDAC_0/SPDT_0/out VSS sky130_fd_pr__nfet_g5v0d10v5 ad=30 pd=27.5 as=30 ps=26 w=10 l=1
X494 CDAC_0/SPDT_0/out CLK5 Vin VDD_5V sky130_fd_pr__pfet_g5v0d10v5 ad=30 pd=26 as=30 ps=26 w=10 l=1
X495 Vin NOT5V_0/Y CDAC_0/SPDT_0/out VSS sky130_fd_pr__nfet_g5v0d10v5 ad=30 pd=26 as=30 ps=26 w=10 l=1
X496 CDAC_0/SPDT_1/out NOT5V_0/Y CDAC_0/b2 VDD_5V sky130_fd_pr__pfet_g5v0d10v5 ad=30 pd=26 as=26.666666 ps=26.666666 w=10 l=1
X497 CDAC_0/b2 CLK5 CDAC_0/SPDT_1/out VSS sky130_fd_pr__nfet_g5v0d10v5 ad=30 pd=27.5 as=30 ps=26 w=10 l=1
X498 CDAC_0/SPDT_1/out CLK5 Vin VDD_5V sky130_fd_pr__pfet_g5v0d10v5 ad=30 pd=26 as=30 ps=26 w=10 l=1
X499 Vin NOT5V_0/Y CDAC_0/SPDT_1/out VSS sky130_fd_pr__nfet_g5v0d10v5 ad=30 pd=26 as=30 ps=26 w=10 l=1
X500 CDAC_0/SPDT_2/out NOT5V_0/Y CDAC_0/b1 VDD_5V sky130_fd_pr__pfet_g5v0d10v5 ad=30 pd=26 as=26.666666 ps=26.666666 w=10 l=1
X501 CDAC_0/b1 CLK5 CDAC_0/SPDT_2/out VSS sky130_fd_pr__nfet_g5v0d10v5 ad=30 pd=27.5 as=30 ps=26 w=10 l=1
X502 CDAC_0/SPDT_2/out CLK5 Vin VDD_5V sky130_fd_pr__pfet_g5v0d10v5 ad=30 pd=26 as=30 ps=26 w=10 l=1
X503 Vin NOT5V_0/Y CDAC_0/SPDT_2/out VSS sky130_fd_pr__nfet_g5v0d10v5 ad=30 pd=26 as=30 ps=26 w=10 l=1
X504 NOT5V_0/Y CLK5 VDD_5V VDD_5V sky130_fd_pr__pfet_g5v0d10v5 ad=2 pd=6 as=2 ps=6.190476 w=2 l=1
X505 NOT5V_0/Y CLK5 VSS VSS sky130_fd_pr__nfet_g5v0d10v5 ad=1 pd=4 as=2.708333 ps=3.0625 w=1 l=1
C0 SAR_validpin_0/DFFR_6/a_90_n400# SAR_validpin_0/OR2_2/A 0.270953f
C1 VDD1v8 SAR_validpin_0/DFFR_3/a_2550_720# 0.013971f
C2 SARclkgen_0/PHIA SAR_validpin_0/DFFRR_0/D 0.203389f
C3 SAR_validpin_0/DFFRR_1/a_1130_520# SAR_validpin_0/DFFRR_1/a_2090_n400# 1.24e-20
C4 CDAC_0/SPDT_4/out CDAC_0/Vcm 0.086211f
C5 shift1v8to5_0/A SAR_validpin_0/DFFRR_1/a_350_n430# 0.00191f
C6 SAR_validpin_0/DFFRR_1/a_1460_n400# SAR_validpin_0/DFFRR_1/a_1130_520# 0.002821f
C7 shift1v8to5_3/A SAR_validpin_0/OR2_1/a_100_310# 0.010242f
C8 SAR_validpin_0/DFFRR_0/a_350_n430# SAR_validpin_0/DFFRR_0/D 0.002086f
C9 SAR_validpin_0/OR2_1/a_n80_n540# SAR_validpin_0/OR2_1/a_100_310# 0.022357f
C10 CDAC_0/SPDT_4/out SAR_validpin_0/OR2_1/B 0.001115f
C11 shift1v8to5_2/A shift1v8to5_3/5v_pfet_1_2_0/D 2.77e-19
C12 shift1v8to5_1/A SAR_validpin_0/DFFR_2/a_2550_720# 0.002813f
C13 RST_N SAR_validpin_0/DFFR_7/a_n50_n400# 0.176481f
C14 SARclkgen_0/PHIB SAR_validpin_0/DFFR_2/a_1310_n400# 0.005571f
C15 SAR_validpin_0/DFFR_4/a_1310_n400# SAR_validpin_0/DFFR_4/a_450_n400# 0.014507f
C16 SRLatch5V_0/NQ shift1v8to5_4/5v_pfet_1_2_0/D 7.06e-19
C17 shift1v8to5_1/A SAR_validpin_0/DFFR_7/a_350_n430# 6.3e-19
C18 SAR_validpin_0/DFFR_2/a_n50_n400# SAR_validpin_0/DFFR_2/a_3210_n400# 2.5e-19
C19 SAR_validpin_0/DFFR_3/a_90_n400# SAR_validpin_0/DFFR_3/a_450_n400# 0.143349f
C20 VDD_5V SAR_validpin_0/DFFR_2/a_n420_n400# 0.003201f
C21 CDAC_0/b0 CDAC_0/b2 0.739939f
C22 SARclkgen_0/PHIA shift1v8to5_0/A 0.324384f
C23 shift5to1v8_0/Y shift1v8to5_3/5v_pfet_1_2_2/D 9.81e-19
C24 SAR_validpin_0/DFFRR_1/a_350_n430# SAR_validpin_0/DFFRR_0/a_1130_520# 4.7e-20
C25 RST_N SAR_validpin_0/DFFR_0/a_2090_n400# 0.532316f
C26 SAR_validpin_0/DFFR_7/a_1310_n400# SAR_validpin_0/DFFR_7/a_350_n430# 0.006999f
C27 SAR_validpin_0/DFFR_0/a_1130_520# SAR_validpin_0/DFFR_0/a_350_n430# 0.24593f
C28 shift1v8to5_2/A SAR_validpin_0/OR2_2/a_n80_n540# 0.330866f
C29 SAR_validpin_0/DFFR_4/a_n50_n400# SAR_validpin_0/DFFR_3/a_1130_520# 3.29e-20
C30 SAR_validpin_0/DFFR_4/a_450_n400# SAR_validpin_0/DFFR_3/a_350_n430# 4.59e-20
C31 VDD_5V SAR_validpin_0/DFFS_0/a_600_n400# 0.007713f
C32 SRLatch5V_0/Q CDAC_0/b2 0.005146f
C33 VALID SAR_validpin_0/DFFRR_0/D 4.77e-19
C34 SAR_validpin_0/DFFS_0/a_350_n430# SAR_validpin_0/DFFR_8/a_n420_n400# 6e-21
C35 SAR_validpin_0/DFFS_0/a_n420_n400# SAR_validpin_0/DFFR_8/a_350_n430# 9.36e-20
C36 SAR_validpin_0/DFFR_8/a_350_n430# shift1v8to5_3/A 9.97e-19
C37 SAR_validpin_0/DFFRR_1/a_n340_n430# SAR_validpin_0/DFFRR_1/a_n420_720# 0.599641f
C38 SAR_validpin_0/DFFRR_1/a_350_n430# SAR_validpin_0/DFFRR_1/a_n930_n400# 0.316122f
C39 SAR_validpin_0/OR2_2/a_n80_n540# SAR_validpin_0/OR2_2/a_100_310# 0.022357f
C40 CDAC_0/SPDT_0/out CDAC_0/Vout 2.479382f
C41 SAR_validpin_0/AND2_0/Y SAR_validpin_0/DFFR_4/a_1460_n400# 0.004103f
C42 SARclkgen_0/PHIA SAR_validpin_0/DFFRR_0/a_1130_520# 2.72e-19
C43 shift1v8to5_2/5v_pfet_1_2_0/D CDAC_0/b1 0.0088f
C44 shift5to1v8_0/Y SAR_validpin_0/DFFR_1/a_90_n400# 0.001599f
C45 RST_N SAR_validpin_0/DFFS_0/a_450_n400# 0.249883f
C46 SAR_validpin_0/DFFRR_0/a_n930_n400# SAR_validpin_0/DFFRR_0/a_1310_n400# 0.001016f
C47 NOT5V_0/Y SARclkgen_0/AND2_0/A 0.002851f
C48 SAR_validpin_0/DFFRR_0/a_350_n430# SAR_validpin_0/DFFRR_0/a_1130_520# 0.24593f
C49 strongarm_0/clk CLK 1.256099f
C50 CLK5 shift1v8to5_0/A 5.88e-19
C51 SAR_validpin_0/DFFR_5/a_2090_n400# SAR_validpin_0/DFFR_6/a_2090_n400# 0.01523f
C52 SARclkgen_0/PHIA SAR_validpin_0/DFFRR_1/a_n930_n400# 0.12333f
C53 SARclkgen_0/PHIB SAR_validpin_0/DFFRR_1/a_350_n430# 0.469911f
C54 SAR_validpin_0/DFFRR_1/a_2600_n430# SAR_validpin_0/DFFR_4/a_90_n400# 2.37e-19
C55 SAR_validpin_0/OR2_1/A SAR_validpin_0/DFFRR_0/a_1460_n400# 0.004288f
C56 SAR_validpin_0/DFFR_8/a_n50_n400# VDD1v8 0.439388f
C57 SAR_validpin_0/DFFR_6/a_1130_520# SAR_validpin_0/DFFR_6/a_1460_n400# 0.002821f
C58 SAR_validpin_0/DFFR_0/a_450_n400# NOT5V_0/Y 1.92e-19
C59 VALID shift1v8to5_0/A 0.345068f
C60 VDD_5V shift1v8to5_0/A 0.79476f
C61 CLK5 CDAC_0/b3 2.725998f
C62 SAR_validpin_0/DFFRR_0/a_350_n430# SAR_validpin_0/DFFRR_1/a_n930_n400# 1.21e-19
C63 SAR_validpin_0/DFFR_5/a_n50_n400# SAR_validpin_0/DFFRR_0/a_2600_n430# 3.44e-19
C64 SAR_validpin_0/DFFR_4/a_n50_n400# SAR_validpin_0/AND2_1/Y 0.224686f
C65 SAR_validpin_0/DFFR_3/a_450_n400# SAR_validpin_0/DFFR_4/a_n420_n400# 2.19e-20
C66 VDD1v8 SAR_validpin_0/DFFR_5/a_1130_520# 0.557738f
C67 VDD1v8 SAR_validpin_0/DFFS_0/a_90_n400# 0.417645f
C68 SARclkgen_0/PHIA SAR_validpin_0/DFFRR_0/a_n560_n400# 2.271439f
C69 SAR_validpin_0/OR2_1/A SAR_validpin_0/OR2_0/B 0.121424f
C70 SAR_validpin_0/DFFR_7/D SAR_validpin_0/DFFRR_0/a_n340_n430# 2.36e-20
C71 SAR_validpin_0/DFFR_5/a_2600_n430# SAR_validpin_0/DFFR_5/a_n50_n400# 0.101518f
C72 SAR_validpin_0/DFFR_4/a_1310_n400# SAR_validpin_0/DFFR_4/a_350_n430# 0.006999f
C73 SARclkgen_0/PHIB SARclkgen_0/PHIA 15.464648f
C74 VDD_5V CDAC_0/b3 1.899966f
C75 VDD1v8 CLK_comp 1.807505f
C76 SAR_validpin_0/DFFR_0/a_1130_520# shift1v8to5_2/A 7.34e-20
C77 SAR_validpin_0/AND2_0/Y SAR_validpin_0/DFFRR_0/a_n560_n400# 0.001378f
C78 SAR_validpin_0/DFFR_6/a_450_n400# SAR_validpin_0/DFFR_6/a_2600_n430# 0.002434f
C79 SAR_validpin_0/DFFR_2/a_n50_n400# SAR_validpin_0/DFFR_2/a_2600_n430# 0.101518f
C80 SARclkgen_0/AND2_0/B SARclkgen_0/AND2_0/a_90_n200# 4.62e-19
C81 SAR_validpin_0/AND2_0/Y SARclkgen_0/PHIB 1.03e-20
C82 SAR_validpin_0/OR2_2/A SAR_validpin_0/DFFRR_0/D 0.126118f
C83 SAR_validpin_0/DFFS_0/a_n50_n400# RST_N 0.061901f
C84 CDAC_0/b1 shift1v8to5_3/5v_pfet_1_2_2/D 0.014008f
C85 SAR_validpin_0/DFFR_7/a_1130_520# SAR_validpin_0/DFFR_7/a_450_n400# 0.171763f
C86 SAR_validpin_0/DFFRR_0/a_350_n430# SAR_validpin_0/DFFRR_0/a_n560_n400# 0.256311f
C87 SAR_validpin_0/DFFRR_0/a_350_n430# SARclkgen_0/PHIB 0.470706f
C88 SAR_validpin_0/DFFRR_0/a_n930_n400# SAR_validpin_0/DFFRR_0/a_450_n400# 0.252379f
C89 SAR_validpin_0/DFFR_1/a_350_n430# shift1v8to5_0/A 2.42e-19
C90 SAR_validpin_0/DFFR_3/a_90_n400# shift1v8to5_1/A 0.001992f
C91 SAR_validpin_0/DFFRR_0/a_n930_n400# SAR_validpin_0/2_1_MUX_1/a_n1230_n310# 0.016671f
C92 SAR_validpin_0/2_1_MUX_2/a_n1230_n310# SAR_validpin_0/DFFRR_0/D 2.21e-20
C93 SAR_validpin_0/DFFR_8/a_1310_n400# SAR_validpin_0/DFFR_8/a_350_n430# 0.006999f
C94 SAR_validpin_0/DFFR_4/a_350_n430# SAR_validpin_0/DFFR_3/a_350_n430# 0.019353f
C95 SAR_validpin_0/DFFR_4/a_2090_n400# SAR_validpin_0/DFFR_4/a_n420_n400# 1.11e-20
C96 SAR_validpin_0/DFFR_2/a_450_n400# SAR_validpin_0/OR2_0/B 0.072736f
C97 VALID SAR_validpin_0/DFFRR_1/a_n930_n400# 8.23e-20
C98 SRLatch5V_0/S CLK 4.42e-19
C99 RST_N SAR_validpin_0/DFFR_1/a_450_n400# 0.312075f
C100 VDD1v8 SAR_validpin_0/DFFR_8/a_2090_n400# 0.917438f
C101 SAR_validpin_0/DFFR_5/a_1460_n400# SAR_validpin_0/DFFR_5/a_1130_520# 0.002821f
C102 SAR_validpin_0/DFFS_0/a_90_n400# CDAC_0/SPDT_2/out 0.001689f
C103 CDAC_0/SPDT_4/out SAR_validpin_0/DFFR_0/a_2600_n430# 0.001074f
C104 SAR_validpin_0/OR2_0/B SAR_validpin_0/DFFRR_1/a_n560_n400# 0.086553f
C105 SAR_validpin_0/DFFR_4/a_450_n400# SAR_validpin_0/DFFR_4/a_1130_520# 0.171763f
C106 SAR_validpin_0/DFFR_2/a_n50_n400# shift1v8to5_1/A 0.098462f
C107 strongarm_0/5v_pfet_1_1_3/D VDD1v8 0.080813f
C108 SAR_validpin_0/OR2_2/A shift1v8to5_0/A 0.038734f
C109 SAR_validpin_0/DFFR_5/a_n420_n400# VDD1v8 0.544819f
C110 CLK5 SARclkgen_0/PHIB 1.82e-19
C111 SAR_validpin_0/DFFR_7/D shift1v8to5_1/A 0.010568f
C112 SAR_validpin_0/DFFRR_1/a_2600_n430# SAR_validpin_0/DFFRR_1/a_3210_n400# 0.011304f
C113 SAR_validpin_0/OR2_1/B SAR_validpin_0/OR2_2/a_n80_n540# 0.060901f
C114 SARclkgen_0/PHIB VALID 0.001733f
C115 SAR_validpin_0/DFFR_5/a_450_n400# SAR_validpin_0/DFFR_5/a_1130_520# 0.171763f
C116 RST_N SAR_validpin_0/DFFR_2/a_2550_720# 0.011485f
C117 shift5to1v8_0/Y SAR_validpin_0/DFFRR_0/D 0.46328f
C118 SAR_validpin_0/DFFS_0/a_n420_n400# CDAC_0/SPDT_3/out 0.002069f
C119 VDD_5V SARclkgen_0/PHIB 1.303864f
C120 SAR_validpin_0/OR2_0/A SAR_validpin_0/DFFR_4/a_n420_n400# 0.093622f
C121 SAR_validpin_0/DFFR_3/a_1460_n400# SAR_validpin_0/DFFR_3/a_450_n400# 0.010382f
C122 RST_N SAR_validpin_0/DFFR_7/a_350_n430# 0.220055f
C123 SAR_validpin_0/DFFR_7/a_2550_720# VDD_5V 0.001002f
C124 SAR_validpin_0/AND2_2/a_n100_1100# SAR_validpin_0/DFFRR_1/a_450_n400# 0.008694f
C125 strongarm_0/clk SRLatch5V_0/NAND5v_1/5v_nfet_1_2_1/D 0.007262f
C126 SAR_validpin_0/DFFR_3/D SAR_validpin_0/DFFR_4/a_90_n400# 0.001334f
C127 SAR_validpin_0/OR2_1/A SAR_validpin_0/DFFR_7/a_2550_n400# 7.38e-19
C128 VDD1v8 SAR_validpin_0/DFFRR_1/a_n340_n430# 0.458949f
C129 SAR_validpin_0/DFFRR_1/a_450_n400# SAR_validpin_0/DFFRR_1/a_n420_720# 0.097799f
C130 CDAC_0/SPDT_0/out shift1v8to5_1/A 0.021455f
C131 SAR_validpin_0/DFFR_0/a_450_n400# CDAC_0/Vout 0.008612f
C132 SAR_validpin_0/AND2_0/Y ADC_OUT2 0.006471f
C133 SAR_validpin_0/OR2_1/a_n80_n540# shift1v8to5_3/A 0.372815f
C134 SAR_validpin_0/DFFR_4/a_n50_n400# SAR_validpin_0/DFFRR_1/a_2090_n400# 4.32e-19
C135 SAR_validpin_0/DFFR_5/a_n420_n400# SAR_validpin_0/DFFR_5/a_1460_n400# 0.001621f
C136 SAR_validpin_0/DFFRR_1/a_2600_n430# SAR_validpin_0/DFFRR_1/a_450_n400# 0.002434f
C137 SARclkgen_0/PHIB SAR_validpin_0/DFFR_1/a_350_n430# 0.551311f
C138 SAR_validpin_0/DFFR_0/a_n50_n400# SAR_validpin_0/DFFR_0/a_3210_n400# 2.5e-19
C139 shift5to1v8_0/Y shift1v8to5_0/A 0.135272f
C140 SAR_validpin_0/DFFR_5/a_1130_520# SAR_validpin_0/AND2_1/Y 0.115688f
C141 SAR_validpin_0/DFFR_4/a_2600_n430# SAR_validpin_0/DFFR_4/a_n50_n400# 0.101518f
C142 VDD1v8 SAR_validpin_0/DFFR_4/a_90_n400# 0.474864f
C143 SAR_validpin_0/DFFR_1/a_1460_n400# SARclkgen_0/PHIA 0.008496f
C144 SAR_validpin_0/DFFR_0/a_n50_n400# SAR_validpin_0/DFFS_0/a_600_n400# 4.23e-19
C145 SAR_validpin_0/AND2_0/a_n100_1100# SARclkgen_0/PHIA 0.443657f
C146 SAR_validpin_0/OR2_1/A SAR_validpin_0/DFFR_7/a_450_n400# 0.009334f
C147 SAR_validpin_0/OR2_2/B CDAC_0/SPDT_3/out 0.002186f
C148 SAR_validpin_0/AND2_0/Y SAR_validpin_0/AND2_0/a_n100_1100# 0.294935f
C149 VDD1v8 SAR_validpin_0/DFFRR_0/a_450_n400# 0.489103f
C150 SAR_validpin_0/DFFRR_0/a_n240_n400# SAR_validpin_0/OR2_1/A 7.49e-19
C151 SAR_validpin_0/OR2_2/A SAR_validpin_0/DFFRR_0/a_n560_n400# 0.010327f
C152 SAR_validpin_0/DFFR_5/a_n420_n400# SAR_validpin_0/DFFR_5/a_450_n400# 0.252386f
C153 VDD1v8 SAR_validpin_0/2_1_MUX_1/a_n1230_n310# 0.294372f
C154 SARclkgen_0/PHIB SAR_validpin_0/OR2_2/A 0.257528f
C155 SAR_validpin_0/DFFR_6/a_n50_n400# SAR_validpin_0/DFFR_5/a_n50_n400# 0.015291f
C156 SAR_validpin_0/DFFR_6/a_1130_520# SAR_validpin_0/DFFR_6/a_350_n430# 0.24593f
C157 SRLatch5V_0/R CLK 2.18e-19
C158 SARclkgen_0/PHIB SAR_validpin_0/2_1_MUX_2/a_n1230_n310# 0.020928f
C159 SAR_validpin_0/DFFR_4/a_1130_520# SAR_validpin_0/DFFR_4/a_350_n430# 0.24593f
C160 SAR_validpin_0/DFFR_2/a_n420_n400# SAR_validpin_0/DFFR_2/a_90_n400# 0.438846f
C161 SAR_validpin_0/DFFR_0/a_450_n400# SAR_validpin_0/DFFR_0/a_90_n400# 0.143231f
C162 SAR_validpin_0/DFFR_0/a_1130_520# SAR_validpin_0/OR2_1/B 0.001359f
C163 SAR_validpin_0/DFFR_7/a_2550_720# SAR_validpin_0/OR2_2/A 0.001302f
C164 SAR_validpin_0/DFFRR_1/a_2550_n400# SAR_validpin_0/OR2_0/A 0.001629f
C165 SAR_validpin_0/DFFS_0/a_n420_n400# SAR_validpin_0/OR2_2/B 0.01286f
C166 VALID ADC_OUT2 0.006731f
C167 shift1v8to5_2/A SAR_validpin_0/DFFR_8/a_350_n430# 8.18e-19
C168 SAR_validpin_0/OR2_2/B shift1v8to5_3/A 0.157331f
C169 SARclkgen_0/PHIA SAR_validpin_0/DFFR_1/a_2600_n430# 0.384149f
C170 SRLatch5V_0/S SRLatch5V_0/NAND5v_1/5v_nfet_1_2_1/D 0.248161f
C171 VDD_5V ADC_OUT2 0.148434f
C172 SAR_validpin_0/AND2_0/Y SAR_validpin_0/DFFR_1/a_2600_n430# 0.002807f
C173 shift5to1v8_0/Y SAR_validpin_0/DFFRR_1/a_n930_n400# 0.542888f
C174 SAR_validpin_0/DFFR_2/a_350_n430# SAR_validpin_0/DFFR_2/a_n420_n400# 0.316282f
C175 SAR_validpin_0/DFFS_0/a_n50_n400# SAR_validpin_0/DFFR_8/a_2600_n430# 0.00154f
C176 SAR_validpin_0/DFFR_0/a_n50_n400# shift1v8to5_0/A 4.3e-19
C177 SAR_validpin_0/DFFRR_0/a_n420_720# SAR_validpin_0/DFFR_7/D 1.25e-20
C178 SAR_validpin_0/AND2_2/a_n100_1100# SAR_validpin_0/DFFR_1/a_90_n400# 0.001916f
C179 SAR_validpin_0/DFFR_3/D SAR_validpin_0/DFFRR_1/a_3210_n400# 0.001084f
C180 SARclkgen_0/PHIA SAR_validpin_0/DFFR_7/a_n420_n400# 0.088985f
C181 SARclkgen_0/PHIA NOT5V_0/Y 0.010737f
C182 SAR_validpin_0/DFFR_6/a_350_n430# SAR_validpin_0/DFFR_6/a_2090_n400# 0.001602f
C183 shift1v8to5_1/A SAR_validpin_0/DFFRR_1/a_2550_n400# 2.67e-19
C184 SAR_validpin_0/DFFR_5/a_n420_n400# SAR_validpin_0/AND2_1/Y 0.772181f
C185 SAR_validpin_0/DFFR_1/a_1460_n400# VDD_5V 9.85e-19
C186 SAR_validpin_0/DFFR_8/a_450_n400# SAR_validpin_0/DFFR_8/a_1460_n400# 0.010382f
C187 SAR_validpin_0/DFFR_3/a_90_n400# RST_N 0.058805f
C188 CLK_comp CDAC_0/b2 0.039569f
C189 SAR_validpin_0/AND2_1/a_n100_1100# SAR_validpin_0/DFFRR_1/a_n560_n400# 9.04e-20
C190 shift5to1v8_0/Y SAR_validpin_0/DFFRR_0/a_n560_n400# 0.01187f
C191 SAR_validpin_0/DFFR_6/a_350_n430# SAR_validpin_0/DFFR_6/a_1310_n400# 0.006999f
C192 SARclkgen_0/PHIB shift5to1v8_0/Y 1.365919f
C193 SAR_validpin_0/DFFRR_1/a_3210_n400# VDD1v8 0.001604f
C194 CDAC_0/b1 shift1v8to5_0/A 0.26516f
C195 SARclkgen_0/PHIA SAR_validpin_0/DFFR_1/a_2090_n400# 0.644576f
C196 SAR_validpin_0/DFFR_0/a_350_n430# CDAC_0/SPDT_3/out 0.003472f
C197 CLK5 SAR_validpin_0/DFFR_1/a_2600_n430# 0.001627f
C198 shift1v8to5_4/5v_pfet_1_2_2/D CLK 0.027784f
C199 SAR_validpin_0/DFFR_2/a_1130_520# SAR_validpin_0/DFFR_3/a_450_n400# 3.51e-19
C200 SAR_validpin_0/DFFR_2/a_n50_n400# RST_N 0.248215f
C201 SAR_validpin_0/DFFR_3/a_n420_n400# SAR_validpin_0/DFFR_3/a_350_n430# 0.316282f
C202 CDAC_0/Vcm CLK 0.056419f
C203 shift1v8to5_2/A SRLatch5V_0/NAND5v_1/5v_nfet_1_2_1/D 0.024806f
C204 CDAC_0/Vcm Vin 0.1098f
C205 CDAC_0/b1 CDAC_0/b3 0.345773f
C206 SAR_validpin_0/DFFR_3/D SAR_validpin_0/DFFRR_1/a_450_n400# 0.002238f
C207 SAR_validpin_0/DFFR_7/D RST_N 0.01206f
C208 SAR_validpin_0/DFFR_1/a_1460_n400# SAR_validpin_0/DFFR_1/a_350_n430# 0.015634f
C209 VDD_5V SAR_validpin_0/DFFR_1/a_2600_n430# 0.005349f
C210 SAR_validpin_0/DFFR_8/a_350_n430# SAR_validpin_0/DFFR_8/a_n420_n400# 0.316282f
C211 SAR_validpin_0/DFFR_7/a_2090_n400# SAR_validpin_0/DFFR_7/a_2550_n400# 0.006257f
C212 SAR_validpin_0/DFFR_1/a_1310_n400# SARclkgen_0/PHIB 0.007219f
C213 CLK5 NOT5V_0/Y 20.662176f
C214 shift1v8to5_1/A SARclkgen_0/AND2_0/A 1.42e-19
C215 RST_N shift1v8to5_4/5v_pfet_1_2_0/D 7.05e-20
C216 SAR_validpin_0/DFFR_0/a_350_n430# shift1v8to5_3/A 4.35e-19
C217 strongarm_0/5v_pfet_1_1_3/D CDAC_0/b2 0.006258f
C218 VALID NOT5V_0/Y 0.041033f
C219 VALID SAR_validpin_0/DFFR_7/a_n420_n400# 4.93e-19
C220 VDD_5V SAR_validpin_0/DFFR_7/a_n420_n400# 0.009429f
C221 shift1v8to5_2/5v_pfet_1_2_0/D VDD1v8 0.722004f
C222 VDD_5V shift1v8to5_1/5v_pfet_1_2_2/D 1.948108f
C223 VDD_5V NOT5V_0/Y 4.834446f
C224 SAR_validpin_0/DFFR_4/a_90_n400# SAR_validpin_0/AND2_1/Y 0.580018f
C225 VDD1v8 shift1v8to5_5/5v_pfet_1_2_2/D 0.557306f
C226 SAR_validpin_0/OR2_1/B SAR_validpin_0/OR2_1/a_100_310# 0.008623f
C227 VDD1v8 SAR_validpin_0/DFFRR_1/a_450_n400# 0.492692f
C228 SAR_validpin_0/DFFR_0/a_450_n400# shift1v8to5_1/A 0.052765f
C229 SAR_validpin_0/DFFR_0/a_n50_n400# SARclkgen_0/PHIB 0.300817f
C230 SARclkgen_0/PHIB SARclkgen_0/AND2_1/a_n100_1100# 0.239415f
C231 SAR_validpin_0/DFFR_7/a_2090_n400# SAR_validpin_0/DFFR_7/a_450_n400# 0.28571f
C232 CLK5 SAR_validpin_0/DFFR_1/a_2090_n400# 1.65e-19
C233 RST_N SAR_validpin_0/DFFR_4/a_n420_n400# 0.284393f
C234 SAR_validpin_0/DFFR_1/a_350_n430# SAR_validpin_0/DFFR_1/a_2600_n430# 2.63e-19
C235 SAR_validpin_0/DFFR_8/a_90_n400# SAR_validpin_0/DFFR_8/a_350_n430# 0.349264f
C236 SRLatch5V_0/NAND5v_1/5v_nfet_1_2_1/D SRLatch5V_0/R 0.303048f
C237 VDD_5V SAR_validpin_0/DFFR_1/a_2090_n400# 0.005656f
C238 SAR_validpin_0/DFFR_1/a_n50_n400# SAR_validpin_0/DFFR_1/a_90_n400# 0.538701f
C239 SAR_validpin_0/DFFR_1/a_350_n430# NOT5V_0/Y 1.67e-19
C240 strongarm_0/clk strongarm_0/5v_nfet_1_1_3/S 0.314743f
C241 SAR_validpin_0/OR2_1/A SAR_validpin_0/DFFRR_0/a_2090_n400# 0.248525f
C242 SRLatch5V_0/NQ SARclkgen_0/PHIA 0.002141f
C243 SAR_validpin_0/DFFR_7/a_450_n400# SAR_validpin_0/DFFR_7/a_n50_n400# 0.819164f
C244 SARclkgen_0/PHIB CDAC_0/b1 0.041614f
C245 SAR_validpin_0/DFFS_0/a_1130_520# shift1v8to5_1/A 0.024431f
C246 SAR_validpin_0/DFFR_0/a_350_n430# SAR_validpin_0/OR2_2/B 0.297161f
C247 SARclkgen_0/PHIA CDAC_0/Vout 0.955849f
C248 SAR_validpin_0/DFFR_6/a_n420_n400# shift1v8to5_1/A 2.38e-19
C249 SAR_validpin_0/OR2_0/B SAR_validpin_0/DFFR_1/a_450_n400# 0.005619f
C250 SAR_validpin_0/DFFR_3/D SAR_validpin_0/DFFR_3/a_1310_n400# 3.34e-19
C251 SAR_validpin_0/2_1_MUX_0/a_n1230_n310# SAR_validpin_0/DFFRR_1/a_350_n430# 7.06e-20
C252 SAR_validpin_0/DFFRR_0/D SAR_validpin_0/DFFRR_1/a_n420_720# 3.16e-19
C253 SARclkgen_0/PHIB SAR_validpin_0/DFFR_2/a_90_n400# 0.582479f
C254 VDD1v8 shift1v8to5_3/5v_pfet_1_2_2/D 0.554625f
C255 SAR_validpin_0/OR2_2/A SAR_validpin_0/DFFR_7/a_n420_n400# 0.069287f
C256 SAR_validpin_0/OR2_2/A NOT5V_0/Y 0.004058f
C257 SAR_validpin_0/DFFS_0/a_1130_520# SAR_validpin_0/DFFS_0/a_1460_n400# 0.002821f
C258 SARclkgen_0/PHIA SAR_validpin_0/DFFR_2/a_3210_n400# 4.1e-19
C259 SAR_validpin_0/DFFR_1/a_350_n430# SAR_validpin_0/DFFR_1/a_2090_n400# 0.001602f
C260 SAR_validpin_0/DFFR_1/a_n420_n400# SAR_validpin_0/DFFR_1/a_90_n400# 0.438846f
C261 SAR_validpin_0/2_1_MUX_2/a_n1230_n310# NOT5V_0/Y 5.44e-20
C262 SAR_validpin_0/DFFS_0/a_600_n400# SAR_validpin_0/DFFR_0/a_n420_n400# 0.010919f
C263 SAR_validpin_0/2_1_MUX_2/a_n1230_n310# SAR_validpin_0/DFFR_7/a_n420_n400# 0.002096f
C264 SAR_validpin_0/DFFR_5/a_2600_n430# SAR_validpin_0/DFFR_6/a_2600_n430# 0.01493f
C265 SAR_validpin_0/DFFR_6/a_90_n400# VDD1v8 0.479139f
C266 CDAC_0/SPDT_1/out shift1v8to5_0/A 0.016169f
C267 shift1v8to5_1/A SAR_validpin_0/DFFR_2/a_1130_520# 0.034697f
C268 shift1v8to5_2/A shift1v8to5_3/A 4.572626f
C269 shift1v8to5_2/A SAR_validpin_0/OR2_1/a_n80_n540# 0.050621f
C270 SARclkgen_0/PHIB SAR_validpin_0/DFFR_2/a_350_n430# 0.471116f
C271 SAR_validpin_0/AND2_2/a_n100_1100# shift1v8to5_0/A 0.068124f
C272 VDD1v8 SAR_validpin_0/DFFR_3/a_1310_n400# 0.001032f
C273 SAR_validpin_0/2_1_MUX_0/a_n1230_n310# SARclkgen_0/PHIA 0.00225f
C274 SAR_validpin_0/DFFR_3/a_n420_n400# SAR_validpin_0/DFFR_4/a_1130_520# 3.28e-20
C275 CDAC_0/b0 Vin 3.203666f
C276 VDD1v8 SAR_validpin_0/DFFR_1/a_90_n400# 0.418534f
C277 shift1v8to5_3/A SAR_validpin_0/OR2_2/a_100_310# 0.010108f
C278 SAR_validpin_0/DFFRR_0/a_n930_n400# SAR_validpin_0/DFFRR_0/D 0.384474f
C279 SARclkgen_0/PHIA SAR_validpin_0/DFFR_0/a_90_n400# 0.094056f
C280 SAR_validpin_0/AND2_0/Y SAR_validpin_0/DFFR_3/a_450_n400# 0.343809f
C281 SAR_validpin_0/DFFRR_1/a_1310_n400# SAR_validpin_0/DFFRR_1/a_350_n430# 0.006999f
C282 CLK5 CDAC_0/Vout 7.895265f
C283 SRLatch5V_0/S strongarm_0/5v_nfet_1_1_3/S 0.023336f
C284 shift1v8to5_1/A SAR_validpin_0/DFFR_2/a_1310_n400# 1.66e-19
C285 RST_N SAR_validpin_0/DFFRR_1/a_2550_n400# 7.85e-19
C286 SAR_validpin_0/DFFR_6/a_450_n400# SAR_validpin_0/DFFR_6/a_n50_n400# 0.819164f
C287 SAR_validpin_0/DFFR_4/a_1310_n400# SAR_validpin_0/DFFR_4/a_n50_n400# 0.006175f
C288 SAR_validpin_0/DFFR_4/a_90_n400# SAR_validpin_0/DFFRR_1/a_2090_n400# 0.001682f
C289 SAR_validpin_0/DFFR_3/a_90_n400# SAR_validpin_0/DFFR_3/a_n50_n400# 0.539174f
C290 SRLatch5V_0/NQ VDD_5V 2.30814f
C291 ADC_OUT0 ADC_OUT2 5.58e-19
C292 VDD_5V CDAC_0/Vout 9.753744f
C293 SRLatch5V_0/S strongarm_0/clk 1.875291f
C294 SAR_validpin_0/DFFR_2/a_n420_n400# SAR_validpin_0/DFFR_1/a_n50_n400# 1.51e-19
C295 shift1v8to5_0/A SAR_validpin_0/DFFR_0/a_n420_n400# 1.28e-19
C296 shift5to1v8_0/Y SAR_validpin_0/DFFR_7/a_n420_n400# 0.466756f
C297 SAR_validpin_0/DFFR_2/a_n420_n400# SAR_validpin_0/DFFR_2/a_2090_n400# 1.11e-20
C298 shift5to1v8_0/Y NOT5V_0/Y 0.211848f
C299 SAR_validpin_0/DFFS_0/a_350_n430# SAR_validpin_0/DFFR_8/a_n50_n400# 7.39e-20
C300 SARclkgen_0/PHIA SAR_validpin_0/DFFRR_1/a_n240_n400# 0.005738f
C301 SAR_validpin_0/DFFR_0/a_3210_n400# SAR_validpin_0/DFFR_1/a_n50_n400# 2.41e-19
C302 SAR_validpin_0/DFFS_0/a_2550_n400# SARclkgen_0/PHIA 0.001936f
C303 SARclkgen_0/PHIA SAR_validpin_0/DFFRR_1/a_1310_n400# 0.003342f
C304 SAR_validpin_0/OR2_2/B shift1v8to5_2/A 0.2843f
C305 SAR_validpin_0/DFFR_3/a_3210_n400# ADC_OUT2 2.27e-19
C306 SRLatch5V_0/R shift1v8to5_3/A 0.001008f
C307 SAR_validpin_0/DFFR_2/a_n50_n400# SAR_validpin_0/DFFR_1/a_3210_n400# 2.41e-19
C308 SAR_validpin_0/DFFR_4/a_n50_n400# SAR_validpin_0/DFFR_3/a_350_n430# 8.42e-20
C309 CDAC_0/b0 shift1v8to5_1/5v_pfet_1_2_0/D 0.337669f
C310 VDD_5V SAR_validpin_0/DFFR_2/a_3210_n400# 0.001782f
C311 SAR_validpin_0/DFFR_2/a_n50_n400# SAR_validpin_0/DFFR_3/a_n50_n400# 0.007866f
C312 SAR_validpin_0/AND2_0/Y ADC_OUT3 0.006471f
C313 SAR_validpin_0/AND2_0/Y SAR_validpin_0/DFFR_4/a_2090_n400# 0.465379f
C314 SRLatch5V_0/NQ SRLatch5V_0/NAND5v_0/5v_nfet_1_2_1/D 0.56708f
C315 SAR_validpin_0/DFFR_8/a_n420_n400# shift1v8to5_3/A 0.003072f
C316 SAR_validpin_0/DFFR_4/a_n50_n400# SAR_validpin_0/DFFR_5/a_n50_n400# 0.006664f
C317 SAR_validpin_0/DFFS_0/a_350_n430# SAR_validpin_0/DFFS_0/a_90_n400# 0.122113f
C318 SAR_validpin_0/2_1_MUX_0/a_n1230_n310# VALID 5.07e-19
C319 SAR_validpin_0/OR2_2/B SAR_validpin_0/OR2_2/a_100_310# 0.007835f
C320 SAR_validpin_0/OR2_0/A SAR_validpin_0/DFFRR_1/a_350_n430# 0.056811f
C321 SAR_validpin_0/DFFR_3/a_1130_520# SAR_validpin_0/DFFR_3/a_1310_n400# 0.002821f
C322 SARclkgen_0/PHIA SAR_validpin_0/DFFRR_0/a_n340_n430# 0.131965f
C323 SAR_validpin_0/DFFRR_1/a_n930_n400# SAR_validpin_0/DFFRR_1/a_n420_720# 0.472823f
C324 SAR_validpin_0/DFFR_1/a_1310_n400# NOT5V_0/Y 4.49e-21
C325 SAR_validpin_0/DFFR_1/a_350_n430# CDAC_0/Vout 0.008096f
C326 shift1v8to5_2/A strongarm_0/5v_nfet_1_1_3/S 0.002149f
C327 RST_N SARclkgen_0/AND2_0/A 1.96e-19
C328 VDD_5V SAR_validpin_0/DFFR_0/a_90_n400# 0.005726f
C329 SARclkgen_0/PHIA SAR_validpin_0/DFFR_2/a_2600_n430# 0.133119f
C330 SAR_validpin_0/DFFRR_1/a_2600_n430# SAR_validpin_0/DFFRR_1/a_n930_n400# 4.26e-20
C331 SAR_validpin_0/AND2_2/a_n100_1100# SARclkgen_0/PHIB 0.02095f
C332 SAR_validpin_0/DFFR_7/a_2090_n400# SAR_validpin_0/DFFRR_0/a_2090_n400# 0.01523f
C333 SAR_validpin_0/DFFRR_0/a_350_n430# SAR_validpin_0/DFFRR_0/a_n340_n430# 0.027962f
C334 SAR_validpin_0/DFFRR_0/a_n930_n400# SAR_validpin_0/DFFRR_0/a_1130_520# 0.088454f
C335 strongarm_0/clk shift1v8to5_2/A 0.007494f
C336 SAR_validpin_0/DFFR_6/a_350_n430# SAR_validpin_0/DFFR_6/a_1460_n400# 0.015634f
C337 VDD1v8 SAR_validpin_0/DFFR_2/a_n420_n400# 0.532528f
C338 SARclkgen_0/PHIA SAR_validpin_0/OR2_0/A 0.247241f
C339 shift1v8to5_1/A SAR_validpin_0/DFFRR_1/a_350_n430# 0.301831f
C340 SAR_validpin_0/DFFR_0/a_450_n400# RST_N 0.317775f
C341 SAR_validpin_0/DFFS_0/a_n420_n400# SAR_validpin_0/DFFR_8/a_90_n400# 2.17e-21
C342 SAR_validpin_0/DFFS_0/a_350_n430# SAR_validpin_0/DFFR_8/a_2090_n400# 3.63e-20
C343 SAR_validpin_0/DFFR_8/a_90_n400# shift1v8to5_3/A 6.23e-19
C344 SAR_validpin_0/DFFR_8/a_1130_520# VDD1v8 0.549954f
C345 SAR_validpin_0/AND2_0/Y SAR_validpin_0/OR2_0/A 0.311373f
C346 SARclkgen_0/PHIB SAR_validpin_0/DFFRR_1/a_n420_720# 0.649896f
C347 SAR_validpin_0/DFFR_0/a_n50_n400# NOT5V_0/Y 2.01e-19
C348 shift1v8to5_2/5v_pfet_1_2_0/D CDAC_0/b2 0.0031f
C349 NOT5V_0/Y SARclkgen_0/AND2_1/a_n100_1100# 2.98e-19
C350 SARclkgen_0/AND2_1/B SARclkgen_0/PHIB 0.667688f
C351 shift1v8to5_0/A SAR_validpin_0/DFFR_1/a_n50_n400# 7.61e-20
C352 SAR_validpin_0/DFFR_3/a_n50_n400# SAR_validpin_0/DFFR_4/a_n420_n400# 2.37e-20
C353 SAR_validpin_0/DFFRR_0/a_n930_n400# SAR_validpin_0/DFFRR_1/a_n930_n400# 0.003453f
C354 SAR_validpin_0/DFFR_7/a_2090_n400# SAR_validpin_0/DFFR_7/a_1130_520# 1.24e-20
C355 VDD1v8 SAR_validpin_0/DFFR_5/a_350_n430# 1.262625f
C356 SAR_validpin_0/DFFRR_1/a_2600_n430# SARclkgen_0/PHIB 4.47e-19
C357 VALID ADC_OUT3 0.7296f
C358 SAR_validpin_0/DFFR_6/a_90_n400# SAR_validpin_0/AND2_1/Y 0.584507f
C359 VDD_5V ADC_OUT3 0.118546f
C360 SAR_validpin_0/AND2_1/a_n100_1100# SAR_validpin_0/DFFR_1/a_450_n400# 0.001966f
C361 VDD1v8 SAR_validpin_0/DFFS_0/a_600_n400# 1.31285f
C362 SAR_validpin_0/DFFR_4/a_2090_n400# VDD_5V 0.024139f
C363 SAR_validpin_0/DFFR_3/a_90_n400# SAR_validpin_0/OR2_0/B 0.053627f
C364 SAR_validpin_0/AND2_1/Y SAR_validpin_0/DFFR_3/a_1310_n400# 0.005716f
C365 shift1v8to5_1/A SARclkgen_0/PHIA 1.832987f
C366 SARclkgen_0/PHIB SAR_validpin_0/DFFR_0/a_n420_n400# 0.757427f
C367 VDD1v8 SAR_validpin_0/DFFRR_0/D 0.862351f
C368 SAR_validpin_0/DFFR_2/a_90_n400# SAR_validpin_0/DFFR_1/a_2600_n430# 2.37e-19
C369 SAR_validpin_0/DFFR_0/a_350_n430# shift1v8to5_2/A 5.46e-20
C370 SAR_validpin_0/DFFS_0/a_1130_520# RST_N 0.371641f
C371 SAR_validpin_0/AND2_0/Y shift1v8to5_1/A 0.00808f
C372 SAR_validpin_0/DFFR_6/a_n50_n400# SAR_validpin_0/DFFR_6/a_2600_n430# 0.101518f
C373 CDAC_0/b1 shift1v8to5_1/5v_pfet_1_2_2/D 0.719977f
C374 SAR_validpin_0/OR2_1/A SAR_validpin_0/DFFRR_1/a_n560_n400# 1.73e-19
C375 SAR_validpin_0/DFFR_7/a_1310_n400# SARclkgen_0/PHIA 0.003645f
C376 SAR_validpin_0/DFFRR_0/a_n930_n400# SAR_validpin_0/DFFRR_0/a_n560_n400# 0.110895f
C377 SAR_validpin_0/OR2_1/B shift1v8to5_3/A 0.166158f
C378 SAR_validpin_0/OR2_1/B SAR_validpin_0/OR2_1/a_n80_n540# 0.190376f
C379 CDAC_0/b1 NOT5V_0/Y 2.870387f
C380 strongarm_0/5v_nfet_1_1_3/S SRLatch5V_0/R 0.154483f
C381 SAR_validpin_0/DFFR_3/D shift1v8to5_0/A 0.005076f
C382 SAR_validpin_0/2_1_MUX_0/a_n1230_n310# SAR_validpin_0/OR2_2/A 0.087833f
C383 SAR_validpin_0/DFFR_6/a_450_n400# SAR_validpin_0/DFFR_7/a_2600_n430# 9.02e-21
C384 SAR_validpin_0/DFFR_7/a_1130_520# SAR_validpin_0/DFFR_7/a_n50_n400# 0.003341f
C385 SAR_validpin_0/DFFR_7/a_350_n430# SAR_validpin_0/DFFR_7/a_450_n400# 0.980343f
C386 SAR_validpin_0/DFFR_6/a_n420_n400# RST_N 0.275103f
C387 SAR_validpin_0/DFFRR_0/a_350_n430# shift1v8to5_1/A 0.276075f
C388 SAR_validpin_0/DFFRR_0/a_n930_n400# SARclkgen_0/PHIB 0.805764f
C389 SAR_validpin_0/DFFR_1/a_n420_n400# shift1v8to5_0/A 7.61e-20
C390 SARclkgen_0/PHIA SAR_validpin_0/DFFS_0/a_1460_n400# 0.009499f
C391 SAR_validpin_0/DFFR_8/a_1310_n400# SAR_validpin_0/DFFR_8/a_n420_n400# 0.001016f
C392 SAR_validpin_0/DFFRR_1/D SAR_validpin_0/DFFRR_1/a_350_n430# 0.002286f
C393 strongarm_0/clk SRLatch5V_0/R 0.998073f
C394 SAR_validpin_0/DFFR_2/a_350_n430# SAR_validpin_0/DFFR_1/a_2600_n430# 3.16e-20
C395 SAR_validpin_0/DFFR_2/a_n50_n400# SAR_validpin_0/OR2_0/B 0.156221f
C396 VDD_5V SAR_validpin_0/DFFR_2/a_2600_n430# 0.041158f
C397 SRLatch5V_0/Q SRLatch5V_0/NAND5v_1/5v_nfet_1_2_1/D 0.498746f
C398 SRLatch5V_0/S shift1v8to5_2/A 0.021604f
C399 SRLatch5V_0/NQ shift5to1v8_0/Y 0.011997f
C400 SAR_validpin_0/OR2_2/B SAR_validpin_0/DFFR_8/a_90_n400# 0.001571f
C401 RST_N SAR_validpin_0/DFFR_2/a_1130_520# 0.441331f
C402 VALID SAR_validpin_0/OR2_0/A 0.007574f
C403 SAR_validpin_0/DFFS_0/a_450_n400# SAR_validpin_0/DFFS_0/a_2090_n400# 0.35927f
C404 SAR_validpin_0/DFFR_5/a_1460_n400# SAR_validpin_0/DFFR_5/a_350_n430# 0.015634f
C405 SAR_validpin_0/DFFR_2/a_n420_n400# SAR_validpin_0/DFFR_3/a_1130_520# 3.28e-20
C406 SAR_validpin_0/AND2_2/a_90_n200# shift5to1v8_0/Y 0.005164f
C407 SAR_validpin_0/DFFRR_1/a_450_n400# SAR_validpin_0/DFFRR_1/a_2090_n400# 0.28571f
C408 shift1v8to5_3/5v_pfet_1_2_2/D CDAC_0/b2 1.513503f
C409 VDD1v8 shift1v8to5_0/A 2.5617f
C410 SAR_validpin_0/DFFR_4/a_n50_n400# SAR_validpin_0/DFFR_4/a_1130_520# 0.003341f
C411 SAR_validpin_0/DFFR_4/a_450_n400# SAR_validpin_0/DFFR_4/a_350_n430# 0.980343f
C412 SAR_validpin_0/DFFRR_1/D SARclkgen_0/PHIA 0.191403f
C413 SAR_validpin_0/DFFRR_1/a_450_n400# SAR_validpin_0/DFFRR_1/a_1460_n400# 0.010382f
C414 CLK5 shift1v8to5_1/A 0.718682f
C415 SAR_validpin_0/DFFR_2/a_90_n400# SAR_validpin_0/DFFR_1/a_2090_n400# 0.001682f
C416 VDD1v8 CDAC_0/b3 1.905101f
C417 shift1v8to5_1/A VALID 0.31621f
C418 strongarm_0/5v_pfet_1_1_0/D SARclkgen_0/AND2_0/A 1.94e-19
C419 RST_N SAR_validpin_0/DFFR_2/a_1310_n400# 0.002531f
C420 VDD_5V shift1v8to5_1/A 1.99471f
C421 VDD1v8 SAR_validpin_0/DFFR_4/a_1460_n400# 9.65e-19
C422 SAR_validpin_0/OR2_1/B SAR_validpin_0/OR2_2/B 0.11522f
C423 SAR_validpin_0/DFFR_5/a_n50_n400# SAR_validpin_0/DFFR_5/a_1130_520# 0.003341f
C424 SAR_validpin_0/DFFR_5/a_450_n400# SAR_validpin_0/DFFR_5/a_350_n430# 0.980343f
C425 SARclkgen_0/PHIB SAR_validpin_0/DFFR_2/a_2090_n400# 2.44e-19
C426 SAR_validpin_0/DFFR_3/a_1460_n400# SAR_validpin_0/DFFR_3/a_n50_n400# 0.006584f
C427 SAR_validpin_0/DFFR_1/a_1310_n400# CDAC_0/Vout 7.38e-19
C428 SAR_validpin_0/DFFR_3/D SAR_validpin_0/DFFRR_1/a_n930_n400# 0.008192f
C429 SARclkgen_0/PHIB SAR_validpin_0/DFFR_1/a_n50_n400# 0.479717f
C430 VDD1v8 SAR_validpin_0/DFFRR_0/a_1130_520# 0.551335f
C431 SAR_validpin_0/2_1_MUX_0/a_n1230_n310# shift5to1v8_0/Y 0.203632f
C432 SAR_validpin_0/DFFR_2/a_350_n430# SAR_validpin_0/DFFR_1/a_2090_n400# 1.34e-19
C433 SAR_validpin_0/AND2_0/Y SAR_validpin_0/DFFR_5/a_2550_n400# 0.001071f
C434 CDAC_0/Vcm strongarm_0/5v_nfet_1_1_3/S 0.22359f
C435 SAR_validpin_0/OR2_2/A SAR_validpin_0/DFFRR_0/a_n340_n430# 0.001617f
C436 SAR_validpin_0/DFFR_7/a_3210_n400# SARclkgen_0/PHIA 4.1e-19
C437 CDAC_0/b0 CDAC_0/SPDT_3/out 1.18733f
C438 VDD_5V SAR_validpin_0/DFFS_0/a_1460_n400# 9.85e-19
C439 SARclkgen_0/PHIB SARclkgen_0/AND2_1/a_90_n200# 0.01331f
C440 shift1v8to5_4/5v_pfet_1_2_2/D strongarm_0/clk 1.121017f
C441 SAR_validpin_0/AND2_0/Y SAR_validpin_0/DFFR_7/a_3210_n400# 0.001496f
C442 SAR_validpin_0/DFFS_0/a_n50_n400# SAR_validpin_0/DFFS_0/a_2090_n400# 0.112583f
C443 strongarm_0/clk CDAC_0/Vcm 0.154454f
C444 SAR_validpin_0/DFFR_2/a_n420_n400# SAR_validpin_0/AND2_1/Y 1.47e-20
C445 shift1v8to5_1/A SAR_validpin_0/DFFR_0/a_2550_720# 0.002813f
C446 SAR_validpin_0/OR2_1/A SAR_validpin_0/DFFR_7/a_2090_n400# 0.003852f
C447 SAR_validpin_0/DFFR_5/a_90_n400# RST_N 0.056267f
C448 VDD1v8 SAR_validpin_0/DFFRR_1/a_n930_n400# 0.47185f
C449 SARclkgen_0/PHIB SAR_validpin_0/DFFR_0/a_1310_n400# 0.007219f
C450 SRLatch5V_0/S SRLatch5V_0/R 3.393579f
C451 SAR_validpin_0/DFFR_0/a_n50_n400# CDAC_0/Vout 0.014181f
C452 SAR_validpin_0/OR2_1/a_n80_n540# SAR_validpin_0/OR2_0/a_n80_n540# 8.66e-19
C453 shift1v8to5_3/A SAR_validpin_0/OR2_0/a_n80_n540# 0.052947f
C454 SARclkgen_0/PHIB SAR_validpin_0/DFFR_3/D 0.151047f
C455 shift1v8to5_1/A SAR_validpin_0/DFFR_1/a_350_n430# 0.151674f
C456 shift1v8to5_2/A SAR_validpin_0/OR2_2/a_100_310# 0.00163f
C457 SARclkgen_0/PHIB SAR_validpin_0/DFFR_1/a_n420_n400# 0.703153f
C458 SAR_validpin_0/OR2_2/A SAR_validpin_0/OR2_0/A 0.142734f
C459 SAR_validpin_0/AND2_0/a_n100_1100# SAR_validpin_0/DFFRR_1/a_2600_n430# 0.002484f
C460 SAR_validpin_0/DFFRR_0/a_n420_720# SARclkgen_0/PHIA 0.095353f
C461 SAR_validpin_0/DFFRR_1/D VALID 8.49e-19
C462 SAR_validpin_0/DFFR_5/a_1310_n400# SAR_validpin_0/DFFR_5/a_1130_520# 0.002821f
C463 SAR_validpin_0/DFFR_5/a_350_n430# SAR_validpin_0/AND2_1/Y 0.470366f
C464 shift5to1v8_0/Y SAR_validpin_0/DFFRR_1/a_1310_n400# 0.002225f
C465 SAR_validpin_0/OR2_1/A SAR_validpin_0/DFFR_7/a_n50_n400# 0.01055f
C466 VDD1v8 SAR_validpin_0/DFFRR_0/a_n560_n400# 0.448605f
C467 SARclkgen_0/PHIB SAR_validpin_0/DFFS_0/a_1310_n400# 0.002283f
C468 SAR_validpin_0/DFFR_5/a_n420_n400# SAR_validpin_0/DFFR_5/a_n50_n400# 0.115835f
C469 SAR_validpin_0/DFFRR_0/a_n420_720# SAR_validpin_0/DFFRR_0/a_350_n430# 0.316859f
C470 SARclkgen_0/PHIB VDD1v8 7.735007f
C471 SRLatch5V_0/Q shift1v8to5_3/A 4.37e-19
C472 CDAC_0/b1 CDAC_0/Vout 2.891643f
C473 CDAC_0/SPDT_1/out NOT5V_0/Y 2.604394f
C474 shift1v8to5_1/A SAR_validpin_0/OR2_2/A 0.007191f
C475 RST_N SAR_validpin_0/DFFRR_1/a_350_n430# 0.210079f
C476 VDD_5V SAR_validpin_0/DFFR_5/a_2550_n400# 5.26e-19
C477 SAR_validpin_0/DFFR_3/a_1130_520# SAR_validpin_0/DFFR_4/a_1460_n400# 2.11e-19
C478 shift5to1v8_0/Y SAR_validpin_0/DFFRR_0/a_n340_n430# 0.002361f
C479 SAR_validpin_0/DFFR_7/a_2550_720# VDD1v8 0.014691f
C480 SAR_validpin_0/DFFRR_0/a_3210_n400# SAR_validpin_0/DFFRR_0/a_n560_n400# 2.5e-19
C481 shift1v8to5_1/A SAR_validpin_0/2_1_MUX_2/a_n1230_n310# 2.87e-19
C482 SAR_validpin_0/DFFR_0/a_350_n430# SAR_validpin_0/OR2_1/B 0.002922f
C483 SAR_validpin_0/OR2_1/A SAR_validpin_0/DFFR_0/a_2090_n400# 1.58e-20
C484 SAR_validpin_0/DFFR_0/a_n50_n400# SAR_validpin_0/DFFR_0/a_90_n400# 0.538701f
C485 shift1v8to5_2/A SRLatch5V_0/R 0.102446f
C486 SAR_validpin_0/DFFR_7/a_1310_n400# SAR_validpin_0/OR2_2/A 0.004188f
C487 SARclkgen_0/AND2_1/B NOT5V_0/Y 0.003085f
C488 VDD_5V SAR_validpin_0/DFFR_6/a_2550_720# 0.001869f
C489 CLK_comp CLK 0.787048f
C490 shift1v8to5_5/5v_pfet_1_2_0/D shift1v8to5_5/5v_pfet_1_2_2/D 0.023009f
C491 shift1v8to5_2/A SAR_validpin_0/DFFR_8/a_n420_n400# 0.004074f
C492 SAR_validpin_0/DFFR_7/D SAR_validpin_0/DFFR_7/a_450_n400# 0.042706f
C493 CLK_comp Vin 0.021064f
C494 CDAC_0/SPDT_4/out SAR_validpin_0/DFFR_1/a_90_n400# 0.003874f
C495 SRLatch5V_0/S CDAC_0/Vcm 0.286982f
C496 SARclkgen_0/PHIB SAR_validpin_0/DFFR_1/a_2550_720# 0.001707f
C497 SAR_validpin_0/OR2_0/a_100_310# shift1v8to5_3/A 0.001619f
C498 SAR_validpin_0/OR2_1/a_n80_n540# SAR_validpin_0/DFFR_0/a_2600_n430# 0.002759f
C499 SAR_validpin_0/DFFR_0/a_2600_n430# shift1v8to5_3/A 3.05e-19
C500 shift5to1v8_0/Y SAR_validpin_0/OR2_0/A 0.54122f
C501 RST_N SARclkgen_0/PHIA 2.220611f
C502 SAR_validpin_0/AND2_0/Y RST_N 0.503764f
C503 SARclkgen_0/PHIB CDAC_0/SPDT_2/out 6.16e-19
C504 NOT5V_0/Y SAR_validpin_0/DFFR_0/a_n420_n400# 0.001198f
C505 SAR_validpin_0/DFFR_4/a_1130_520# SAR_validpin_0/DFFR_5/a_1130_520# 0.009107f
C506 SARclkgen_0/PHIB SAR_validpin_0/DFFR_7/a_90_n400# 0.583868f
C507 SAR_validpin_0/DFFR_3/a_n420_n400# SAR_validpin_0/DFFR_3/a_2600_n430# 4.26e-20
C508 SAR_validpin_0/DFFR_6/a_350_n430# SAR_validpin_0/DFFR_7/a_2090_n400# 1.34e-19
C509 SAR_validpin_0/DFFR_5/a_1310_n400# SAR_validpin_0/DFFR_5/a_n420_n400# 0.001016f
C510 SAR_validpin_0/DFFR_1/a_1460_n400# SAR_validpin_0/DFFR_1/a_n50_n400# 0.006584f
C511 SAR_validpin_0/DFFRR_0/a_350_n430# RST_N 0.210079f
C512 SAR_validpin_0/DFFRR_1/D SAR_validpin_0/OR2_2/A 0.163795f
C513 SAR_validpin_0/DFFRR_0/a_n930_n400# SAR_validpin_0/DFFR_7/a_n420_n400# 0.00575f
C514 shift1v8to5_1/A shift5to1v8_0/Y 0.899502f
C515 SAR_validpin_0/DFFR_7/a_1130_520# SAR_validpin_0/DFFR_7/a_350_n430# 0.24593f
C516 SAR_validpin_0/DFFR_8/a_90_n400# shift1v8to5_2/A 4e-19
C517 SAR_validpin_0/DFFR_4/a_2090_n400# ADC_OUT0 3.07e-20
C518 SAR_validpin_0/AND2_1/Y SAR_validpin_0/DFFR_4/a_1460_n400# 0.009764f
C519 SAR_validpin_0/DFFR_8/a_n50_n400# SAR_validpin_0/DFFR_8/a_350_n430# 0.260805f
C520 CDAC_0/Vcm shift1v8to5_2/A 5.49e-19
C521 SARclkgen_0/AND2_0/a_n100_1100# SARclkgen_0/AND2_0/A 0.387637f
C522 CLK5 RST_N 0.829488f
C523 SAR_validpin_0/AND2_0/a_n100_1100# SAR_validpin_0/DFFR_3/D 0.029617f
C524 SAR_validpin_0/DFFR_7/a_3210_n400# SAR_validpin_0/OR2_2/A 0.006701f
C525 VDD1v8 ADC_OUT2 0.192346f
C526 SAR_validpin_0/DFFR_1/a_1460_n400# SAR_validpin_0/DFFR_1/a_n420_n400# 0.001621f
C527 SAR_validpin_0/DFFR_1/a_n50_n400# SAR_validpin_0/DFFR_1/a_2600_n430# 0.101518f
C528 SAR_validpin_0/OR2_1/B shift1v8to5_2/A 0.178032f
C529 RST_N VALID 4.011223f
C530 shift1v8to5_0/A CDAC_0/b2 0.14865f
C531 strongarm_0/clk SRLatch5V_0/Q 1.48e-19
C532 VDD_5V RST_N 2.126199f
C533 SAR_validpin_0/DFFR_3/a_n420_n400# SAR_validpin_0/DFFR_4/a_450_n400# 2.19e-20
C534 SAR_validpin_0/DFFR_5/a_n420_n400# SAR_validpin_0/DFFR_4/a_1130_520# 3.28e-20
C535 SAR_validpin_0/DFFR_8/a_2550_720# SAR_validpin_0/DFFR_8/a_2090_n400# 0.011347f
C536 NOT5V_0/Y SAR_validpin_0/DFFR_1/a_n50_n400# 4.2e-20
C537 SAR_validpin_0/DFFRR_1/D shift5to1v8_0/Y 0.613503f
C538 CDAC_0/b3 CDAC_0/b2 6.555335f
C539 SAR_validpin_0/OR2_1/B SAR_validpin_0/OR2_2/a_100_310# 0.001885f
C540 SAR_validpin_0/DFFRR_0/a_n420_720# SAR_validpin_0/OR2_2/A 0.002799f
C541 SAR_validpin_0/AND2_0/a_n100_1100# VDD1v8 0.712592f
C542 SAR_validpin_0/AND2_0/a_n100_1100# SAR_validpin_0/AND2_0/a_90_n200# 0.011051f
C543 shift1v8to5_1/A SARclkgen_0/AND2_1/a_n100_1100# 2.36e-19
C544 CDAC_0/SPDT_1/out CDAC_0/Vout 2.15466f
C545 SAR_validpin_0/DFFR_0/a_n50_n400# shift1v8to5_1/A 0.081222f
C546 SAR_validpin_0/AND2_1/Y SAR_validpin_0/DFFRR_0/a_n560_n400# 0.002206f
C547 SARclkgen_0/PHIB SAR_validpin_0/AND2_1/Y 0.01715f
C548 CDAC_0/SPDT_4/out SAR_validpin_0/DFFR_0/a_3210_n400# 2.69e-19
C549 SAR_validpin_0/DFFR_7/a_2090_n400# SAR_validpin_0/DFFR_7/a_n50_n400# 0.596801f
C550 SAR_validpin_0/DFFR_1/a_n420_n400# SAR_validpin_0/DFFR_1/a_2600_n430# 4.26e-20
C551 RST_N SAR_validpin_0/DFFR_0/a_2550_720# 0.01019f
C552 SAR_validpin_0/AND2_2/a_n100_1100# SAR_validpin_0/AND2_2/a_90_n200# 0.011051f
C553 SAR_validpin_0/DFFR_8/a_2090_n400# SAR_validpin_0/DFFR_8/a_350_n430# 0.001602f
C554 SAR_validpin_0/DFFR_8/a_90_n400# SAR_validpin_0/DFFR_8/a_n420_n400# 0.438846f
C555 SAR_validpin_0/DFFR_0/a_1310_n400# NOT5V_0/Y 2.24e-20
C556 shift1v8to5_4/5v_pfet_1_2_2/D SRLatch5V_0/R 6.5e-19
C557 shift1v8to5_1/A ADC_OUT0 0.486515f
C558 RST_N SAR_validpin_0/DFFR_1/a_350_n430# 0.231558f
C559 CDAC_0/Vcm SRLatch5V_0/R 0.39791f
C560 shift1v8to5_3/5v_pfet_1_2_2/D shift1v8to5_3/5v_pfet_1_2_0/D 0.022299f
C561 SAR_validpin_0/DFFR_1/a_n420_n400# NOT5V_0/Y 4.89e-20
C562 SAR_validpin_0/DFFR_2/a_350_n430# SAR_validpin_0/DFFR_2/a_2600_n430# 2.63e-19
C563 SAR_validpin_0/DFFR_1/a_n50_n400# SAR_validpin_0/DFFR_1/a_2090_n400# 0.596801f
C564 SAR_validpin_0/DFFR_6/a_450_n400# SAR_validpin_0/DFFR_5/a_1130_520# 9.74e-20
C565 VDD1v8 SAR_validpin_0/DFFR_1/a_2600_n430# 1.00399f
C566 shift1v8to5_1/A CDAC_0/b1 0.589548f
C567 SAR_validpin_0/DFFR_0/a_n420_n400# CDAC_0/Vout 0.006615f
C568 shift1v8to5_1/A SAR_validpin_0/DFFR_2/a_90_n400# 0.032367f
C569 SAR_validpin_0/DFFR_2/a_1130_520# SAR_validpin_0/OR2_0/B 0.003863f
C570 SAR_validpin_0/DFFR_0/a_350_n430# SAR_validpin_0/DFFR_0/a_2600_n430# 2.63e-19
C571 VDD1v8 shift1v8to5_1/5v_pfet_1_2_2/D 0.581846f
C572 VDD1v8 NOT5V_0/Y 2.764155f
C573 SAR_validpin_0/2_1_MUX_0/a_n1230_n310# SAR_validpin_0/DFFRR_1/a_n420_720# 0.001973f
C574 SAR_validpin_0/OR2_1/A SAR_validpin_0/DFFR_7/a_350_n430# 0.005449f
C575 VDD1v8 SAR_validpin_0/DFFR_7/a_n420_n400# 0.481229f
C576 RST_N SAR_validpin_0/OR2_2/A 0.286625f
C577 SRLatch5V_0/S SRLatch5V_0/Q 0.317187f
C578 SAR_validpin_0/DFFS_0/a_1310_n400# NOT5V_0/Y 2.24e-20
C579 RST_N SAR_validpin_0/2_1_MUX_2/a_n1230_n310# 0.00478f
C580 SAR_validpin_0/DFFRR_0/a_n420_720# shift5to1v8_0/Y 0.001786f
C581 SAR_validpin_0/DFFR_7/a_2600_n430# SAR_validpin_0/DFFRR_0/a_2600_n430# 0.01493f
C582 SAR_validpin_0/DFFR_3/D SAR_validpin_0/DFFR_1/a_2090_n400# 1.02e-20
C583 SAR_validpin_0/DFFR_1/a_n420_n400# SAR_validpin_0/DFFR_1/a_2090_n400# 1.11e-20
C584 shift1v8to5_1/A SAR_validpin_0/DFFR_2/a_350_n430# 0.066975f
C585 SARclkgen_0/PHIB CDAC_0/b2 0.046352f
C586 SAR_validpin_0/OR2_0/B SAR_validpin_0/DFFR_2/a_1310_n400# 1.5e-19
C587 SAR_validpin_0/DFFR_8/a_2600_n430# SARclkgen_0/PHIA 0.136155f
C588 SAR_validpin_0/DFFR_5/a_3210_n400# SAR_validpin_0/DFFR_5/a_n50_n400# 2.5e-19
C589 SAR_validpin_0/DFFR_4/a_2090_n400# SAR_validpin_0/DFFR_4/a_2550_n400# 0.006257f
C590 CDAC_0/b0 shift1v8to5_2/A 7.44e-20
C591 CLK5 strongarm_0/5v_pfet_1_1_0/D 5.13e-20
C592 SAR_validpin_0/DFFR_6/a_n420_n400# SAR_validpin_0/DFFR_6/a_1130_520# 0.088465f
C593 SARclkgen_0/PHIA SAR_validpin_0/DFFR_1/a_3210_n400# 0.008626f
C594 strongarm_0/5v_pfet_1_1_3/D SRLatch5V_0/NAND5v_1/5v_nfet_1_2_1/D 2.9e-19
C595 VDD1v8 SAR_validpin_0/DFFR_1/a_2090_n400# 0.934183f
C596 SAR_validpin_0/DFFR_0/a_n420_n400# SAR_validpin_0/DFFR_0/a_90_n400# 0.438846f
C597 VDD_5V strongarm_0/5v_pfet_1_1_0/D 0.555124f
C598 SAR_validpin_0/DFFR_6/a_450_n400# SAR_validpin_0/DFFR_5/a_n420_n400# 2.19e-20
C599 SAR_validpin_0/AND2_0/Y SAR_validpin_0/DFFR_3/a_n50_n400# 1.886265f
C600 SAR_validpin_0/DFFRR_1/a_n930_n400# SAR_validpin_0/DFFRR_1/a_2090_n400# 1.11e-20
C601 SAR_validpin_0/DFFRR_1/a_n420_720# SAR_validpin_0/DFFRR_1/a_n240_n400# 0.011322f
C602 SAR_validpin_0/DFFR_7/a_n420_n400# SAR_validpin_0/DFFR_7/a_90_n400# 0.438846f
C603 SAR_validpin_0/DFFRR_1/a_1460_n400# SAR_validpin_0/DFFRR_1/a_n930_n400# 0.001621f
C604 SRLatch5V_0/Q shift1v8to5_2/A 0.030042f
C605 NOT5V_0/Y CDAC_0/SPDT_2/out 2.677323f
C606 SAR_validpin_0/DFFS_0/a_90_n400# CDAC_0/SPDT_3/out 0.002185f
C607 SAR_validpin_0/DFFS_0/a_1130_520# SAR_validpin_0/DFFR_8/a_450_n400# 4.89e-19
C608 RST_N shift5to1v8_0/Y 0.037231f
C609 CDAC_0/Vout SAR_validpin_0/DFFR_1/a_n50_n400# 0.015402f
C610 SAR_validpin_0/DFFS_0/a_n420_n400# SAR_validpin_0/DFFR_8/a_n50_n400# 2.65e-20
C611 SAR_validpin_0/DFFS_0/a_350_n430# SAR_validpin_0/DFFR_8/a_1130_520# 0.002522f
C612 SAR_validpin_0/DFFR_8/a_n50_n400# shift1v8to5_3/A 6.38e-19
C613 SAR_validpin_0/DFFR_6/a_n420_n400# SAR_validpin_0/DFFR_6/a_2090_n400# 1.11e-20
C614 SAR_validpin_0/DFFRR_1/a_n420_720# SAR_validpin_0/DFFRR_0/a_n340_n430# 3.16e-19
C615 SAR_validpin_0/DFFR_1/a_2090_n400# SAR_validpin_0/DFFR_1/a_2550_720# 0.011347f
C616 SAR_validpin_0/AND2_0/a_n100_1100# SAR_validpin_0/AND2_1/Y 0.436546f
C617 SARclkgen_0/PHIB SAR_validpin_0/DFFRR_1/a_2090_n400# 2.44e-19
C618 SARclkgen_0/PHIB SAR_validpin_0/DFFRR_1/a_1460_n400# 0.009764f
C619 SAR_validpin_0/AND2_2/a_n100_1100# SAR_validpin_0/OR2_0/A 0.009091f
C620 SAR_validpin_0/DFFR_6/a_n420_n400# SAR_validpin_0/DFFR_6/a_1310_n400# 0.001016f
C621 SAR_validpin_0/DFFR_0/a_1310_n400# CDAC_0/Vout 7.38e-19
C622 SAR_validpin_0/DFFS_0/a_n420_n400# SAR_validpin_0/DFFS_0/a_90_n400# 0.472877f
C623 SAR_validpin_0/DFFS_0/a_350_n430# SAR_validpin_0/DFFS_0/a_600_n400# 0.624749f
C624 SAR_validpin_0/DFFR_8/a_2600_n430# VALID 0.782065f
C625 SAR_validpin_0/DFFR_3/a_350_n430# SAR_validpin_0/DFFR_3/a_1310_n400# 0.006999f
C626 SAR_validpin_0/DFFR_1/a_n420_n400# CDAC_0/Vout 0.006524f
C627 SAR_validpin_0/OR2_0/B SAR_validpin_0/DFFRR_1/a_350_n430# 0.002354f
C628 SAR_validpin_0/OR2_0/A SAR_validpin_0/DFFRR_1/a_n420_720# 0.059151f
C629 SAR_validpin_0/AND2_2/a_90_n200# SAR_validpin_0/DFFR_3/D 1.83e-19
C630 SAR_validpin_0/DFFR_4/a_450_n400# SAR_validpin_0/DFFR_4/a_n50_n400# 0.819164f
C631 CDAC_0/SPDT_4/out SARclkgen_0/PHIB 0.001266f
C632 VDD_5V SAR_validpin_0/DFFR_3/a_n50_n400# 0.004559f
C633 shift1v8to5_5/5v_pfet_1_2_2/D CLK 0.635785f
C634 SAR_validpin_0/DFFRR_1/a_2600_n430# SAR_validpin_0/OR2_0/A 0.825174f
C635 SAR_validpin_0/DFFRR_0/a_1460_n400# SARclkgen_0/PHIA 0.00387f
C636 SAR_validpin_0/DFFRR_0/a_n930_n400# SAR_validpin_0/DFFRR_0/a_n340_n430# 0.052622f
C637 SAR_validpin_0/AND2_2/a_n100_1100# shift1v8to5_1/A 0.725753f
C638 SRLatch5V_0/Q SRLatch5V_0/R 2.000866f
C639 SARclkgen_0/AND2_0/a_90_n200# SARclkgen_0/AND2_0/A 0.006918f
C640 SRLatch5V_0/NQ VDD1v8 1.249678f
C641 SAR_validpin_0/DFFR_0/a_n50_n400# RST_N 0.21081f
C642 VDD1v8 CDAC_0/Vout 0.166934f
C643 RST_N SARclkgen_0/AND2_1/a_n100_1100# 3.75e-19
C644 SAR_validpin_0/DFFR_8/a_n50_n400# SAR_validpin_0/DFFR_8/a_3210_n400# 2.36e-19
C645 SAR_validpin_0/DFFRR_0/a_350_n430# SAR_validpin_0/DFFRR_0/a_1460_n400# 0.015634f
C646 SAR_validpin_0/DFFS_0/a_1310_n400# CDAC_0/Vout 5.79e-19
C647 SARclkgen_0/PHIA SARclkgen_0/AND2_0/a_n100_1100# 0.088168f
C648 SAR_validpin_0/DFFS_0/a_n420_n400# SAR_validpin_0/DFFR_8/a_2090_n400# 7.49e-20
C649 SAR_validpin_0/DFFR_8/a_2090_n400# shift1v8to5_3/A 7.42e-19
C650 shift1v8to5_1/A SAR_validpin_0/DFFRR_1/a_n420_720# 0.12092f
C651 SARclkgen_0/PHIA SAR_validpin_0/OR2_0/B 0.892181f
C652 SARclkgen_0/AND2_1/B shift1v8to5_1/A 1.43e-19
C653 SAR_validpin_0/AND2_2/a_90_n200# VDD1v8 2.38e-19
C654 SARclkgen_0/AND2_0/B SARclkgen_0/AND2_0/A 0.590274f
C655 SAR_validpin_0/AND2_0/Y SAR_validpin_0/OR2_0/B 0.056647f
C656 SAR_validpin_0/DFFRR_1/a_2600_n430# shift1v8to5_1/A 0.001334f
C657 SAR_validpin_0/DFFR_7/a_2090_n400# SAR_validpin_0/DFFR_7/a_350_n430# 0.001602f
C658 RST_N ADC_OUT0 0.450655f
C659 SAR_validpin_0/DFFR_1/a_450_n400# SAR_validpin_0/DFFR_0/a_2090_n400# 2.95e-20
C660 SAR_validpin_0/AND2_0/Y ADC_OUT1 0.006471f
C661 SAR_validpin_0/DFFR_3/D SAR_validpin_0/DFFR_3/a_450_n400# 0.046331f
C662 shift1v8to5_2/5v_pfet_1_2_0/D shift1v8to5_1/5v_pfet_1_2_0/D 0.002408f
C663 SAR_validpin_0/OR2_1/A SAR_validpin_0/DFFR_7/D 0.006338f
C664 SAR_validpin_0/DFFR_8/a_n50_n400# SAR_validpin_0/DFFR_8/a_1310_n400# 0.006175f
C665 shift1v8to5_1/A SAR_validpin_0/DFFR_0/a_n420_n400# 0.073977f
C666 SAR_validpin_0/DFFS_0/a_n50_n400# SAR_validpin_0/DFFS_0/a_450_n400# 0.698426f
C667 RST_N SAR_validpin_0/DFFR_3/a_3210_n400# 0.004852f
C668 SAR_validpin_0/DFFRR_1/a_2550_720# VDD1v8 0.014691f
C669 SAR_validpin_0/2_1_MUX_0/a_n1230_n310# VDD1v8 0.298306f
C670 CDAC_0/Vcm CDAC_0/b0 0.198672f
C671 shift1v8to5_0/A shift1v8to5_3/5v_pfet_1_2_0/D 0.061642f
C672 SAR_validpin_0/OR2_1/B SAR_validpin_0/OR2_0/a_n80_n540# 4.28e-19
C673 SAR_validpin_0/AND2_1/Y SAR_validpin_0/DFFR_1/a_2090_n400# 3.86e-19
C674 SAR_validpin_0/DFFR_6/a_n50_n400# SAR_validpin_0/DFFR_7/a_2600_n430# 3.69e-19
C675 SAR_validpin_0/DFFR_7/a_350_n430# SAR_validpin_0/DFFR_7/a_n50_n400# 0.260805f
C676 SAR_validpin_0/DFFR_2/a_450_n400# SAR_validpin_0/DFFR_2/a_n50_n400# 0.819164f
C677 RST_N SAR_validpin_0/DFFR_2/a_90_n400# 0.10845f
C678 SAR_validpin_0/DFFRR_0/a_n930_n400# shift1v8to5_1/A 0.097521f
C679 VDD1v8 SAR_validpin_0/DFFR_0/a_90_n400# 0.413086f
C680 SAR_validpin_0/DFFR_3/a_450_n400# VDD1v8 0.52139f
C681 SAR_validpin_0/DFFR_4/a_2600_n430# ADC_OUT2 7.13e-19
C682 CDAC_0/SPDT_2/out CDAC_0/Vout 1.956946f
C683 SAR_validpin_0/DFFR_2/a_2090_n400# SAR_validpin_0/DFFR_2/a_2600_n430# 0.594476f
C684 SAR_validpin_0/DFFRR_1/D SAR_validpin_0/DFFRR_1/a_n420_720# 0.406681f
C685 CLK5 SAR_validpin_0/OR2_0/B 4.61e-20
C686 CLK5 SARclkgen_0/AND2_0/a_n100_1100# 4.64e-19
C687 shift1v8to5_0/A SAR_validpin_0/OR2_2/a_n80_n540# 0.103384f
C688 RST_N SAR_validpin_0/DFFR_2/a_350_n430# 0.256914f
C689 SAR_validpin_0/OR2_0/A SAR_validpin_0/DFFR_1/a_n50_n400# 8.91e-19
C690 SAR_validpin_0/DFFR_2/a_n420_n400# SAR_validpin_0/DFFR_3/a_350_n430# 1.21e-19
C691 SAR_validpin_0/AND2_0/Y SAR_validpin_0/DFFR_6/a_1130_520# 2.72e-19
C692 VALID SAR_validpin_0/OR2_0/B 0.002601f
C693 strongarm_0/clk CLK_comp 1.686311f
C694 NOT5V_0/Y CDAC_0/b2 1.731424f
C695 SAR_validpin_0/AND2_0/a_n100_1100# SAR_validpin_0/DFFRR_1/a_2090_n400# 7.72e-19
C696 VDD_5V SAR_validpin_0/OR2_0/B 0.00726f
C697 VDD_5V SARclkgen_0/AND2_0/a_n100_1100# 0.012392f
C698 SAR_validpin_0/AND2_0/Y SAR_validpin_0/DFFR_6/a_3210_n400# 4.1e-19
C699 SAR_validpin_0/DFFR_4/a_n50_n400# SAR_validpin_0/DFFR_4/a_350_n430# 0.260805f
C700 VDD_5V ADC_OUT1 0.116551f
C701 SAR_validpin_0/DFFR_0/a_450_n400# SAR_validpin_0/DFFS_0/a_2090_n400# 5.13e-21
C702 VDD1v8 ADC_OUT3 0.168159f
C703 SAR_validpin_0/DFFR_4/a_2090_n400# VDD1v8 0.918708f
C704 SAR_validpin_0/DFFR_4/a_1130_520# SAR_validpin_0/DFFR_3/a_1310_n400# 2.11e-19
C705 SAR_validpin_0/DFFR_5/a_n50_n400# SAR_validpin_0/DFFR_5/a_350_n430# 0.260805f
C706 shift1v8to5_1/A SAR_validpin_0/DFFR_1/a_n50_n400# 0.076813f
C707 SAR_validpin_0/DFFS_0/a_350_n430# SARclkgen_0/PHIB 0.128853f
C708 SAR_validpin_0/DFFR_8/a_450_n400# SARclkgen_0/PHIA 0.344781f
C709 SARclkgen_0/PHIA SAR_validpin_0/DFFR_7/a_2550_n400# 0.001071f
C710 shift1v8to5_1/A SAR_validpin_0/DFFR_2/a_2090_n400# 0.317947f
C711 SARclkgen_0/PHIB SAR_validpin_0/DFFR_1/a_1130_520# 0.131883f
C712 SAR_validpin_0/DFFR_3/D SAR_validpin_0/OR2_0/A 0.093056f
C713 SAR_validpin_0/AND2_0/Y SAR_validpin_0/DFFR_6/a_2090_n400# 0.465379f
C714 VDD1v8 SAR_validpin_0/DFFRR_0/a_n340_n430# 0.454503f
C715 SAR_validpin_0/OR2_1/B SAR_validpin_0/DFFR_0/a_2600_n430# 0.947304f
C716 strongarm_0/5v_pfet_1_1_3/D strongarm_0/5v_nfet_1_1_3/S 0.143298f
C717 SAR_validpin_0/DFFR_1/a_n420_n400# SAR_validpin_0/OR2_0/A 1.24e-20
C718 SAR_validpin_0/AND2_0/Y SAR_validpin_0/DFFR_7/a_2550_n400# 2.18e-19
C719 SAR_validpin_0/DFFR_1/a_350_n430# SAR_validpin_0/OR2_0/B 0.00803f
C720 SAR_validpin_0/DFFR_4/a_450_n400# SAR_validpin_0/DFFR_5/a_1130_520# 3.51e-19
C721 strongarm_0/5v_pfet_1_1_3/D strongarm_0/clk 0.236466f
C722 SAR_validpin_0/DFFR_4/a_n420_n400# SAR_validpin_0/DFFRR_1/a_n560_n400# 1.51e-19
C723 SAR_validpin_0/DFFRR_0/a_n420_720# SAR_validpin_0/DFFRR_1/a_n420_720# 0.003608f
C724 VDD1v8 SAR_validpin_0/DFFR_2/a_2600_n430# 0.971182f
C725 SAR_validpin_0/DFFR_3/a_450_n400# SAR_validpin_0/DFFR_3/a_1130_520# 0.171763f
C726 SAR_validpin_0/DFFRR_0/a_1460_n400# SAR_validpin_0/OR2_2/A 8.42e-19
C727 SAR_validpin_0/AND2_0/Y SAR_validpin_0/DFFR_6/a_1310_n400# 0.003645f
C728 SAR_validpin_0/DFFR_6/a_1130_520# VALID 7.53e-19
C729 SAR_validpin_0/DFFR_6/a_1130_520# VDD_5V 0.0079f
C730 shift1v8to5_1/A SAR_validpin_0/DFFR_1/a_n420_n400# 0.091444f
C731 SAR_validpin_0/AND2_0/a_90_n200# SAR_validpin_0/OR2_0/A 0.00117f
C732 shift1v8to5_1/A SAR_validpin_0/DFFR_3/D 0.348779f
C733 SARclkgen_0/PHIA SAR_validpin_0/DFFR_7/a_450_n400# 0.343737f
C734 SAR_validpin_0/DFFR_4/a_2550_720# SAR_validpin_0/DFFR_4/a_2090_n400# 0.011347f
C735 VDD1v8 SAR_validpin_0/OR2_0/A 0.831884f
C736 SAR_validpin_0/DFFS_0/a_3210_n400# NOT5V_0/Y 4.44e-20
C737 SAR_validpin_0/AND2_2/a_90_n200# SAR_validpin_0/AND2_1/Y 1.25e-20
C738 SRLatch5V_0/S CLK_comp 0.012721f
C739 VDD_5V SAR_validpin_0/DFFR_6/a_3210_n400# 0.001782f
C740 RST_N SAR_validpin_0/DFFR_4/a_2550_n400# 7.85e-19
C741 SAR_validpin_0/DFFRR_0/a_n240_n400# SARclkgen_0/PHIA 0.009858f
C742 SAR_validpin_0/OR2_2/A SAR_validpin_0/OR2_0/B 0.290795f
C743 SAR_validpin_0/DFFR_5/a_1310_n400# SAR_validpin_0/DFFR_5/a_350_n430# 0.006999f
C744 SARclkgen_0/PHIB SAR_validpin_0/OR2_2/a_n80_n540# 8.77e-21
C745 SAR_validpin_0/DFFR_0/a_1130_520# shift1v8to5_0/A 2.43e-19
C746 SAR_validpin_0/DFFRR_0/a_350_n430# SAR_validpin_0/DFFR_7/a_450_n400# 4.59e-20
C747 SAR_validpin_0/DFFR_7/a_90_n400# SAR_validpin_0/DFFRR_0/a_n340_n430# 0.004766f
C748 SAR_validpin_0/DFFR_8/a_2550_n400# SARclkgen_0/PHIA 0.001071f
C749 SAR_validpin_0/AND2_1/a_n100_1100# SARclkgen_0/PHIA 0.029652f
C750 SAR_validpin_0/DFFR_7/a_1460_n400# SAR_validpin_0/DFFRR_0/a_1130_520# 2.11e-19
C751 SAR_validpin_0/DFFRR_0/a_n420_720# SAR_validpin_0/DFFRR_0/a_n930_n400# 0.472823f
C752 shift1v8to5_1/A VDD1v8 9.766252f
C753 SAR_validpin_0/DFFR_8/a_450_n400# VALID 1.9e-19
C754 VALID SAR_validpin_0/DFFR_6/a_2090_n400# 8.6e-19
C755 CDAC_0/SPDT_4/out NOT5V_0/Y 3.547621f
C756 shift1v8to5_1/A SAR_validpin_0/DFFS_0/a_1310_n400# 1.53e-19
C757 SAR_validpin_0/AND2_2/a_n100_1100# RST_N 0.002549f
C758 SAR_validpin_0/AND2_0/Y SAR_validpin_0/AND2_1/a_n100_1100# 4.78e-19
C759 SAR_validpin_0/OR2_2/B SAR_validpin_0/2_1_MUX_1/a_n1230_n310# 0.012272f
C760 VDD_5V SAR_validpin_0/DFFR_6/a_2090_n400# 0.035841f
C761 SAR_validpin_0/DFFR_8/a_n50_n400# shift1v8to5_2/A 3.87e-19
C762 RST_N SAR_validpin_0/DFFRR_1/a_n420_720# 0.054503f
C763 SARclkgen_0/AND2_1/B RST_N 1.97e-19
C764 SAR_validpin_0/DFFR_3/a_450_n400# SAR_validpin_0/AND2_1/Y 0.79898f
C765 strongarm_0/5v_pfet_1_1_3/D SRLatch5V_0/S 0.331488f
C766 SAR_validpin_0/AND2_0/Y SAR_validpin_0/DFFR_4/a_3210_n400# 4.1e-19
C767 SAR_validpin_0/DFFRR_1/a_2600_n430# RST_N 0.602242f
C768 VDD_5V shift1v8to5_0/5v_pfet_1_2_2/D 2.038458f
C769 SRLatch5V_0/NQ CDAC_0/b2 0.008941f
C770 SAR_validpin_0/DFFR_7/D SAR_validpin_0/DFFR_7/a_n50_n400# 0.131321f
C771 SAR_validpin_0/DFFR_6/a_450_n400# SAR_validpin_0/DFFR_6/a_90_n400# 0.143349f
C772 SAR_validpin_0/DFFR_3/a_n50_n400# ADC_OUT0 0.014855f
C773 SAR_validpin_0/OR2_0/a_100_310# SAR_validpin_0/OR2_0/a_n80_n540# 0.022357f
C774 CDAC_0/SPDT_4/out SAR_validpin_0/DFFR_1/a_2090_n400# 0.003029f
C775 CLK_comp shift1v8to5_2/A 0.001244f
C776 CDAC_0/Vout CDAC_0/b2 2.158909f
C777 shift1v8to5_1/A SAR_validpin_0/DFFR_1/a_2550_720# 0.002813f
C778 SAR_validpin_0/AND2_1/a_90_n200# SAR_validpin_0/DFFR_3/D 0.004003f
C779 SAR_validpin_0/DFFR_6/a_n420_n400# SAR_validpin_0/DFFR_6/a_1460_n400# 0.001621f
C780 SAR_validpin_0/AND2_0/Y SAR_validpin_0/DFFR_3/a_2090_n400# 0.465379f
C781 RST_N SAR_validpin_0/DFFR_0/a_n420_n400# 0.363951f
C782 VALID SAR_validpin_0/DFFR_7/a_450_n400# 9.65e-19
C783 VDD_5V SAR_validpin_0/DFFR_7/a_450_n400# 0.012267f
C784 SAR_validpin_0/DFFR_4/a_1130_520# SAR_validpin_0/DFFR_5/a_350_n430# 4.7e-20
C785 SAR_validpin_0/DFFR_4/a_350_n430# SAR_validpin_0/DFFR_5/a_1130_520# 4.7e-20
C786 SAR_validpin_0/DFFR_3/a_n50_n400# SAR_validpin_0/DFFR_3/a_3210_n400# 2.5e-19
C787 shift5to1v8_0/Y SAR_validpin_0/OR2_0/B 0.159872f
C788 shift1v8to5_1/A CDAC_0/SPDT_2/out 2.54e-19
C789 SARclkgen_0/PHIA SARclkgen_0/AND2_0/a_90_n200# 2.1e-19
C790 shift1v8to5_1/A SAR_validpin_0/DFFR_7/a_90_n400# 2.72e-19
C791 SAR_validpin_0/DFFRR_0/a_n930_n400# RST_N 0.185891f
C792 SAR_validpin_0/DFFR_0/a_450_n400# SAR_validpin_0/DFFR_0/a_1460_n400# 0.010382f
C793 SAR_validpin_0/DFFRR_1/D VDD1v8 0.884304f
C794 SARclkgen_0/PHIB SAR_validpin_0/DFFR_7/a_1460_n400# 0.009764f
C795 SAR_validpin_0/DFFR_4/a_2090_n400# SAR_validpin_0/AND2_1/Y 2.44e-19
C796 SAR_validpin_0/DFFR_2/a_1460_n400# SAR_validpin_0/DFFR_2/a_n420_n400# 0.001621f
C797 SAR_validpin_0/DFFR_1/a_1460_n400# SAR_validpin_0/DFFR_1/a_1130_520# 0.002821f
C798 SAR_validpin_0/DFFR_8/a_2550_n400# VALID 3.8e-19
C799 SAR_validpin_0/DFFR_5/a_n420_n400# SAR_validpin_0/DFFRR_0/a_2600_n430# 0.130292f
C800 SAR_validpin_0/DFFR_5/a_90_n400# SAR_validpin_0/DFFRR_0/a_2090_n400# 0.001682f
C801 SAR_validpin_0/DFFR_5/a_3210_n400# SAR_validpin_0/DFFR_6/a_2600_n430# 9.33e-20
C802 SARclkgen_0/AND2_0/B SARclkgen_0/PHIA 0.405803f
C803 SARclkgen_0/PHIB SAR_validpin_0/DFFR_3/a_350_n430# 1.85e-20
C804 shift1v8to5_1/A SAR_validpin_0/DFFR_3/a_1130_520# 0.002785f
C805 SAR_validpin_0/DFFR_8/a_2090_n400# shift1v8to5_2/A 5.77e-19
C806 SAR_validpin_0/DFFR_5/a_n50_n400# SAR_validpin_0/DFFRR_0/a_n560_n400# 0.001519f
C807 SAR_validpin_0/DFFR_8/a_1130_520# SAR_validpin_0/DFFR_8/a_350_n430# 0.24593f
C808 SAR_validpin_0/DFFR_8/a_n50_n400# SAR_validpin_0/DFFR_8/a_n420_n400# 0.116062f
C809 SAR_validpin_0/DFFR_1/a_2550_n400# SAR_validpin_0/DFFR_1/a_2090_n400# 0.006257f
C810 SAR_validpin_0/OR2_2/A SAR_validpin_0/DFFR_7/a_2550_n400# 0.001645f
C811 SAR_validpin_0/DFFR_5/a_2600_n430# SAR_validpin_0/DFFR_5/a_n420_n400# 4.26e-20
C812 SAR_validpin_0/DFFR_4/a_450_n400# SAR_validpin_0/DFFR_4/a_90_n400# 0.143349f
C813 SARclkgen_0/PHIB SAR_validpin_0/DFFR_0/a_1130_520# 0.117164f
C814 strongarm_0/5v_pfet_1_1_3/D shift1v8to5_2/A 0.017878f
C815 SAR_validpin_0/DFFR_7/a_3210_n400# VDD1v8 0.001604f
C816 SAR_validpin_0/DFFR_6/a_2550_720# VDD1v8 0.013971f
C817 VDD_5V SAR_validpin_0/DFFR_4/a_3210_n400# 0.001782f
C818 shift1v8to5_5/5v_pfet_1_2_0/D NOT5V_0/Y 0.004748f
C819 Vin CDAC_0/b3 0.928584f
C820 CLK_comp SRLatch5V_0/R 0.047327f
C821 shift1v8to5_0/A SAR_validpin_0/OR2_1/a_100_310# 0.014588f
C822 SAR_validpin_0/DFFS_0/a_3210_n400# CDAC_0/Vout 0.001142f
C823 VDD_5V SAR_validpin_0/DFFR_3/a_2090_n400# 0.024139f
C824 SAR_validpin_0/DFFS_0/a_600_n400# SAR_validpin_0/DFFR_8/a_350_n430# 0.001999f
C825 SAR_validpin_0/OR2_0/A SAR_validpin_0/AND2_1/Y 0.403798f
C826 SAR_validpin_0/DFFR_2/a_2550_n400# SARclkgen_0/PHIA 0.001071f
C827 SAR_validpin_0/DFFR_1/a_350_n430# SAR_validpin_0/AND2_1/a_n100_1100# 0.006225f
C828 SARclkgen_0/AND2_0/a_n100_1100# SARclkgen_0/AND2_1/a_n100_1100# 0.003228f
C829 SAR_validpin_0/DFFR_3/a_n420_n400# SAR_validpin_0/DFFR_4/a_n50_n400# 2.37e-20
C830 RST_N SAR_validpin_0/DFFR_2/a_2090_n400# 0.525243f
C831 RST_N SAR_validpin_0/DFFR_1/a_n50_n400# 0.206684f
C832 SAR_validpin_0/DFFR_5/a_n420_n400# SAR_validpin_0/DFFR_4/a_350_n430# 1.21e-19
C833 SAR_validpin_0/OR2_2/A SAR_validpin_0/DFFR_7/a_450_n400# 0.176122f
C834 SAR_validpin_0/DFFRR_0/a_n420_720# VDD1v8 0.608038f
C835 SAR_validpin_0/DFFS_0/a_350_n430# NOT5V_0/Y 5.95e-19
C836 SAR_validpin_0/DFFR_7/a_450_n400# SAR_validpin_0/2_1_MUX_2/a_n1230_n310# 5.3e-20
C837 SAR_validpin_0/DFFR_8/a_n50_n400# SAR_validpin_0/DFFR_8/a_90_n400# 0.538622f
C838 shift1v8to5_3/5v_pfet_1_2_2/D shift1v8to5_3/A 0.690041f
C839 VDD_5V SARclkgen_0/AND2_0/a_90_n200# 9.53e-19
C840 CDAC_0/SPDT_4/out CDAC_0/Vout 2.579296f
C841 SAR_validpin_0/DFFR_8/a_2550_720# shift1v8to5_0/A 1.75e-20
C842 SAR_validpin_0/DFFRR_0/a_n240_n400# SAR_validpin_0/OR2_2/A 5.96e-19
C843 SARclkgen_0/PHIA SAR_validpin_0/DFFS_0/a_2090_n400# 0.336043f
C844 SAR_validpin_0/DFFRR_1/a_2550_720# SAR_validpin_0/DFFRR_1/a_2090_n400# 0.011347f
C845 CLK5 SARclkgen_0/AND2_0/B 1.81e-19
C846 ADC_OUT1 ADC_OUT0 0.346195f
C847 shift1v8to5_1/A SAR_validpin_0/AND2_1/Y 0.209077f
C848 SAR_validpin_0/DFFR_4/a_1130_520# SAR_validpin_0/DFFR_4/a_1460_n400# 0.002821f
C849 SARclkgen_0/PHIA SAR_validpin_0/DFFRR_0/a_2090_n400# 0.465379f
C850 CDAC_0/b3 shift1v8to5_1/5v_pfet_1_2_0/D 5.06e-20
C851 SAR_validpin_0/AND2_0/Y SAR_validpin_0/DFFRR_0/a_2090_n400# 0.002786f
C852 SAR_validpin_0/DFFR_8/a_2090_n400# SAR_validpin_0/DFFR_8/a_n420_n400# 1.11e-20
C853 SAR_validpin_0/DFFRR_0/a_2600_n430# SAR_validpin_0/DFFRR_0/a_450_n400# 0.002434f
C854 SAR_validpin_0/DFFR_3/a_3210_n400# ADC_OUT1 4.15e-19
C855 VDD_5V SARclkgen_0/AND2_0/B 0.01193f
C856 strongarm_0/5v_pfet_1_1_3/D SRLatch5V_0/R 0.478329f
C857 RST_N SAR_validpin_0/DFFR_3/D 0.098631f
C858 RST_N SAR_validpin_0/DFFR_1/a_n420_n400# 0.366304f
C859 shift1v8to5_0/A SAR_validpin_0/DFFR_8/a_350_n430# 0.015182f
C860 SAR_validpin_0/DFFR_1/a_1130_520# SAR_validpin_0/DFFR_1/a_2090_n400# 1.24e-20
C861 SAR_validpin_0/DFFRR_0/a_350_n430# SAR_validpin_0/DFFRR_0/a_2090_n400# 0.001602f
C862 SAR_validpin_0/DFFR_6/a_450_n400# SAR_validpin_0/DFFR_5/a_350_n430# 4.59e-20
C863 SAR_validpin_0/DFFR_6/a_n50_n400# SAR_validpin_0/DFFR_5/a_1130_520# 3.29e-20
C864 SAR_validpin_0/DFFR_2/a_90_n400# SAR_validpin_0/OR2_0/B 0.381055f
C865 SARclkgen_0/PHIB CLK 0.237945f
C866 shift1v8to5_4/5v_pfet_1_2_2/D CLK_comp 0.702669f
C867 SAR_validpin_0/DFFR_7/a_1130_520# SARclkgen_0/PHIA 2.72e-19
C868 SAR_validpin_0/AND2_0/Y SAR_validpin_0/DFFR_5/a_2090_n400# 0.465379f
C869 SAR_validpin_0/DFFR_1/a_2550_n400# CDAC_0/Vout 9.77e-19
C870 strongarm_0/clk shift1v8to5_5/5v_pfet_1_2_2/D 0.003824f
C871 SAR_validpin_0/DFFR_2/a_450_n400# SAR_validpin_0/DFFR_2/a_1130_520# 0.171763f
C872 CDAC_0/Vcm CLK_comp 0.215549f
C873 SAR_validpin_0/AND2_0/a_90_n200# RST_N 0.002225f
C874 SAR_validpin_0/DFFRR_0/a_n420_720# SAR_validpin_0/DFFR_7/a_90_n400# 0.004766f
C875 RST_N VDD1v8 24.49181f
C876 SAR_validpin_0/DFFR_2/a_2550_n400# VDD_5V 5.26e-19
C877 shift5to1v8_0/Y SAR_validpin_0/DFFR_7/a_450_n400# 0.001286f
C878 SAR_validpin_0/DFFR_5/a_n50_n400# ADC_OUT2 0.015377f
C879 SAR_validpin_0/DFFR_2/a_350_n430# SAR_validpin_0/OR2_0/B 0.254399f
C880 CLK5 SAR_validpin_0/DFFS_0/a_2090_n400# 8.13e-21
C881 SAR_validpin_0/DFFR_4/a_90_n400# SAR_validpin_0/DFFR_4/a_350_n430# 0.349264f
C882 SARclkgen_0/PHIB SAR_validpin_0/OR2_1/a_100_310# 0.006754f
C883 RST_N SAR_validpin_0/DFFRR_0/a_3210_n400# 0.005107f
C884 SAR_validpin_0/DFFR_4/a_2090_n400# SAR_validpin_0/DFFR_4/a_2600_n430# 0.594476f
C885 VDD_5V SAR_validpin_0/DFFS_0/a_2090_n400# 0.00739f
C886 shift1v8to5_1/A CDAC_0/b2 0.170219f
C887 SAR_validpin_0/AND2_0/a_n100_1100# SAR_validpin_0/DFFR_3/a_350_n430# 2.19e-19
C888 SAR_validpin_0/AND2_1/a_90_n200# SAR_validpin_0/AND2_1/Y 3.45e-19
C889 SAR_validpin_0/DFFR_2/a_450_n400# SAR_validpin_0/DFFR_2/a_1310_n400# 0.014507f
C890 SAR_validpin_0/AND2_0/Y SAR_validpin_0/DFFR_6/a_1460_n400# 0.00384f
C891 SAR_validpin_0/OR2_1/A SAR_validpin_0/DFFR_5/a_90_n400# 0.272055f
C892 SAR_validpin_0/DFFR_6/a_n420_n400# SAR_validpin_0/DFFR_6/a_350_n430# 0.316282f
C893 RST_N SAR_validpin_0/DFFR_1/a_2550_720# 0.01019f
C894 shift1v8to5_2/5v_pfet_1_2_2/D VDD_5V 1.721542f
C895 SAR_validpin_0/DFFR_7/D SAR_validpin_0/DFFR_7/a_350_n430# 0.213011f
C896 SAR_validpin_0/DFFR_4/a_2550_720# RST_N 0.011485f
C897 SAR_validpin_0/DFFR_2/a_1460_n400# SARclkgen_0/PHIB 0.009764f
C898 SAR_validpin_0/DFFR_5/a_2090_n400# VDD_5V 0.024139f
C899 SAR_validpin_0/DFFR_7/a_1130_520# VALID 7.53e-19
C900 SAR_validpin_0/DFFR_6/a_n50_n400# SAR_validpin_0/DFFR_5/a_n420_n400# 2.37e-20
C901 RST_N SAR_validpin_0/DFFR_7/a_90_n400# 0.058783f
C902 SAR_validpin_0/OR2_0/A SAR_validpin_0/DFFRR_1/a_2090_n400# 0.246828f
C903 VDD_5V SAR_validpin_0/DFFR_7/a_1130_520# 0.0079f
C904 SAR_validpin_0/OR2_0/A SAR_validpin_0/DFFRR_1/a_1460_n400# 0.004288f
C905 SAR_validpin_0/DFFR_7/a_1460_n400# SAR_validpin_0/DFFR_7/a_n420_n400# 0.001621f
C906 SAR_validpin_0/DFFS_0/a_600_n400# CDAC_0/SPDT_3/out 0.004726f
C907 SARclkgen_0/PHIB SAR_validpin_0/DFFR_8/a_350_n430# 0.470269f
C908 SAR_validpin_0/DFFS_0/a_350_n430# CDAC_0/Vout 0.006345f
C909 SAR_validpin_0/DFFS_0/a_n420_n400# SAR_validpin_0/DFFR_8/a_1130_520# 4.63e-21
C910 SAR_validpin_0/DFFR_8/a_1130_520# shift1v8to5_3/A 8.93e-20
C911 RST_N SAR_validpin_0/DFFR_3/a_1130_520# 0.430407f
C912 shift1v8to5_1/A SAR_validpin_0/DFFRR_1/a_2090_n400# 0.001227f
C913 SAR_validpin_0/DFFR_6/a_n420_n400# SAR_validpin_0/DFFR_7/a_2090_n400# 0.010629f
C914 RST_N SAR_validpin_0/DFFR_5/a_450_n400# 0.295291f
C915 SARclkgen_0/PHIA SAR_validpin_0/DFFR_0/a_1460_n400# 0.0081f
C916 CDAC_0/b1 shift1v8to5_0/5v_pfet_1_2_2/D 2.033863f
C917 shift1v8to5_1/A SAR_validpin_0/DFFRR_1/a_1460_n400# 5.38e-19
C918 SAR_validpin_0/DFFR_0/a_450_n400# SAR_validpin_0/DFFR_0/a_2090_n400# 0.28571f
C919 SAR_validpin_0/DFFR_4/a_2600_n430# shift1v8to5_1/A 0.00263f
C920 SAR_validpin_0/DFFS_0/a_n420_n400# SAR_validpin_0/DFFS_0/a_600_n400# 0.322659f
C921 SAR_validpin_0/OR2_1/A SARclkgen_0/PHIA 0.48861f
C922 SAR_validpin_0/AND2_2/a_n100_1100# SAR_validpin_0/OR2_0/B 0.079224f
C923 SAR_validpin_0/OR2_1/B SAR_validpin_0/DFFRR_1/a_n340_n430# 6.81e-20
C924 SAR_validpin_0/OR2_2/A SAR_validpin_0/DFFRR_0/a_2090_n400# 0.003932f
C925 SAR_validpin_0/DFFR_6/a_n420_n400# SAR_validpin_0/DFFR_7/a_n50_n400# 1.51e-19
C926 SAR_validpin_0/AND2_0/Y SAR_validpin_0/OR2_1/A 0.311724f
C927 SAR_validpin_0/DFFR_1/a_3210_n400# SAR_validpin_0/DFFR_1/a_n50_n400# 2.5e-19
C928 shift1v8to5_2/5v_pfet_1_2_0/D shift1v8to5_2/A 0.460039f
C929 VDD1v8 strongarm_0/5v_pfet_1_1_0/D 0.003859f
C930 SAR_validpin_0/OR2_0/B SAR_validpin_0/DFFRR_1/a_n420_720# 0.010813f
C931 SAR_validpin_0/DFFR_5/a_3210_n400# SAR_validpin_0/DFFR_5/a_2600_n430# 0.011304f
C932 SARclkgen_0/AND2_1/B SARclkgen_0/AND2_0/a_n100_1100# 0.202989f
C933 SAR_validpin_0/DFFRR_0/a_350_n430# SAR_validpin_0/OR2_1/A 0.075922f
C934 SAR_validpin_0/DFFRR_1/a_n560_n400# SAR_validpin_0/DFFRR_1/a_350_n430# 0.256311f
C935 SAR_validpin_0/DFFR_0/a_450_n400# SAR_validpin_0/DFFS_0/a_450_n400# 3.89e-21
C936 SAR_validpin_0/DFFRR_1/a_2600_n430# SAR_validpin_0/OR2_0/B 8.19e-20
C937 SAR_validpin_0/DFFR_7/a_1130_520# SAR_validpin_0/OR2_2/A 0.011365f
C938 SAR_validpin_0/DFFR_2/a_450_n400# SARclkgen_0/PHIA 0.350213f
C939 SAR_validpin_0/DFFR_5/a_2550_720# RST_N 0.011485f
C940 RST_N SAR_validpin_0/AND2_1/Y 1.68406f
C941 SAR_validpin_0/DFFRR_0/a_n930_n400# SAR_validpin_0/DFFRR_0/a_1460_n400# 0.001621f
C942 CLK_comp SRLatch5V_0/Q 0.003403f
C943 shift5to1v8_0/5v_pfet_1_2_1/G shift1v8to5_4/5v_pfet_1_2_0/D 0.002474f
C944 SAR_validpin_0/OR2_1/B SAR_validpin_0/DFFRR_0/a_450_n400# 6.46e-21
C945 ADC_OUT0 SAR_validpin_0/DFFR_3/a_2090_n400# 0.190286f
C946 shift1v8to5_0/A shift1v8to5_3/A 3.380378f
C947 SAR_validpin_0/OR2_1/B SAR_validpin_0/2_1_MUX_1/a_n1230_n310# 0.527389f
C948 shift1v8to5_0/A SAR_validpin_0/OR2_1/a_n80_n540# 0.103859f
C949 SARclkgen_0/PHIA SAR_validpin_0/DFFRR_1/a_n560_n400# 2.21537f
C950 SAR_validpin_0/DFFRR_1/a_1130_520# SAR_validpin_0/DFFRR_0/a_450_n400# 3.51e-19
C951 SAR_validpin_0/DFFS_0/a_600_n400# SAR_validpin_0/OR2_2/B 0.260116f
C952 SAR_validpin_0/DFFR_3/D SAR_validpin_0/DFFR_3/a_n50_n400# 0.08793f
C953 CDAC_0/b3 shift1v8to5_3/A 0.011371f
C954 SAR_validpin_0/AND2_0/Y SAR_validpin_0/DFFRR_1/a_n560_n400# 0.001378f
C955 SAR_validpin_0/DFFRR_0/D SAR_validpin_0/OR2_2/B 0.022615f
C956 SAR_validpin_0/DFFR_8/a_1130_520# SAR_validpin_0/DFFR_8/a_1310_n400# 0.002821f
C957 shift1v8to5_0/5v_pfet_1_2_0/D shift1v8to5_0/A 0.460332f
C958 SAR_validpin_0/2_1_MUX_0/a_n1230_n310# SAR_validpin_0/OR2_2/a_n80_n540# 0.002998f
C959 SAR_validpin_0/DFFS_0/a_1130_520# SAR_validpin_0/DFFS_0/a_450_n400# 0.173318f
C960 SAR_validpin_0/OR2_1/A VALID 0.020097f
C961 SAR_validpin_0/DFFR_8/a_2600_n430# VDD1v8 0.967864f
C962 shift1v8to5_3/5v_pfet_1_2_2/D shift1v8to5_2/A 0.323078f
C963 NOT5V_0/Y CLK 0.583828f
C964 VDD1v8 SAR_validpin_0/DFFR_1/a_3210_n400# 0.001163f
C965 NOT5V_0/Y Vin 6.650689f
C966 SAR_validpin_0/DFFR_3/a_n50_n400# VDD1v8 0.505663f
C967 strongarm_0/5v_pfet_1_1_3/D SRLatch5V_0/Q 3.61e-20
C968 SAR_validpin_0/DFFRR_1/a_n340_n430# SAR_validpin_0/OR2_0/a_n80_n540# 0.00429f
C969 SAR_validpin_0/AND2_0/Y SAR_validpin_0/DFFR_6/a_350_n430# 0.071104f
C970 CDAC_0/SPDT_1/out shift1v8to5_0/5v_pfet_1_2_2/D 0.015253f
C971 SAR_validpin_0/DFFR_2/a_450_n400# VDD_5V 0.003549f
C972 SAR_validpin_0/OR2_2/B shift1v8to5_0/A 0.204177f
C973 SAR_validpin_0/DFFR_8/a_3210_n400# shift1v8to5_0/A 0.001783f
C974 SAR_validpin_0/DFFRR_1/a_n930_n400# shift1v8to5_3/A 7e-21
C975 SAR_validpin_0/OR2_1/a_n80_n540# SAR_validpin_0/DFFRR_1/a_n930_n400# 0.003779f
C976 SARclkgen_0/PHIA SAR_validpin_0/DFFR_8/a_1460_n400# 0.003641f
C977 SARclkgen_0/PHIB CDAC_0/SPDT_3/out 0.001744f
C978 SAR_validpin_0/OR2_0/B SAR_validpin_0/DFFR_1/a_n50_n400# 0.023619f
C979 SAR_validpin_0/DFFR_0/a_n50_n400# SAR_validpin_0/DFFS_0/a_2090_n400# 2.51e-19
C980 SAR_validpin_0/DFFS_0/a_n50_n400# SAR_validpin_0/DFFS_0/a_1130_520# 0.014955f
C981 shift1v8to5_1/5v_pfet_1_2_2/D shift1v8to5_1/5v_pfet_1_2_0/D 0.023009f
C982 NOT5V_0/Y shift1v8to5_1/5v_pfet_1_2_0/D 0.004064f
C983 shift1v8to5_0/A SAR_validpin_0/DFFR_8/a_1310_n400# 0.001532f
C984 shift1v8to5_1/A SAR_validpin_0/DFFR_1/a_1130_520# 0.064469f
C985 SARclkgen_0/PHIB shift1v8to5_3/A 0.220765f
C986 SAR_validpin_0/DFFS_0/a_n420_n400# SARclkgen_0/PHIB 1.658959f
C987 SAR_validpin_0/DFFS_0/a_350_n430# shift1v8to5_1/A 0.360758f
C988 shift1v8to5_3/5v_pfet_1_2_2/D SRLatch5V_0/R 5.27e-19
C989 SAR_validpin_0/DFFR_0/a_350_n430# SAR_validpin_0/DFFS_0/a_600_n400# 8.04e-20
C990 SARclkgen_0/PHIB SAR_validpin_0/OR2_1/a_n80_n540# 0.111159f
C991 SAR_validpin_0/DFFR_7/a_2090_n400# SARclkgen_0/PHIA 0.465379f
C992 SAR_validpin_0/OR2_1/A SAR_validpin_0/OR2_2/A 0.409701f
C993 strongarm_0/5v_nfet_1_1_3/S CDAC_0/b3 6.12e-20
C994 SAR_validpin_0/DFFR_1/a_n420_n400# SAR_validpin_0/OR2_0/B 0.003185f
C995 SAR_validpin_0/DFFR_3/D SAR_validpin_0/OR2_0/B 0.46527f
C996 SAR_validpin_0/OR2_1/A SAR_validpin_0/2_1_MUX_2/a_n1230_n310# 0.005423f
C997 SAR_validpin_0/AND2_0/Y SAR_validpin_0/DFFR_7/a_2090_n400# 0.002682f
C998 SAR_validpin_0/AND2_2/a_n100_1100# SAR_validpin_0/AND2_1/a_n100_1100# 0.005207f
C999 SAR_validpin_0/DFFS_0/a_350_n430# SAR_validpin_0/DFFS_0/a_1460_n400# 0.015634f
C1000 SAR_validpin_0/DFFR_3/a_n50_n400# SAR_validpin_0/DFFR_3/a_1130_520# 0.003341f
C1001 SAR_validpin_0/DFFR_3/a_450_n400# SAR_validpin_0/DFFR_3/a_350_n430# 0.980343f
C1002 RST_N SAR_validpin_0/DFFRR_1/a_2090_n400# 0.471887f
C1003 SAR_validpin_0/OR2_0/A SAR_validpin_0/OR2_2/a_n80_n540# 0.003787f
C1004 strongarm_0/clk CDAC_0/b3 5.6e-19
C1005 SAR_validpin_0/DFFR_6/a_350_n430# VALID 0.001114f
C1006 SAR_validpin_0/DFFR_6/a_350_n430# VDD_5V 0.0182f
C1007 shift1v8to5_2/5v_pfet_1_2_2/D CDAC_0/b1 0.014421f
C1008 SARclkgen_0/PHIA SAR_validpin_0/DFFR_7/a_n50_n400# 1.863387f
C1009 SAR_validpin_0/DFFR_4/a_2600_n430# RST_N 0.623992f
C1010 VDD1v8 SARclkgen_0/AND2_0/a_n100_1100# 0.711672f
C1011 VDD1v8 SAR_validpin_0/OR2_0/B 3.014072f
C1012 SAR_validpin_0/AND2_0/Y SAR_validpin_0/DFFR_7/a_n50_n400# 0.001362f
C1013 VDD1v8 ADC_OUT1 0.173779f
C1014 SAR_validpin_0/DFFRR_1/a_450_n400# SAR_validpin_0/DFFRR_1/a_1130_520# 0.171763f
C1015 SAR_validpin_0/DFFR_0/a_350_n430# shift1v8to5_0/A 2.42e-19
C1016 SAR_validpin_0/DFFRR_0/a_n930_n400# SAR_validpin_0/DFFR_7/a_450_n400# 2.19e-20
C1017 SAR_validpin_0/DFFRR_0/a_350_n430# SAR_validpin_0/DFFR_7/a_n50_n400# 8.42e-20
C1018 CDAC_0/SPDT_4/out RST_N 6.43e-19
C1019 shift1v8to5_1/A SAR_validpin_0/OR2_2/a_n80_n540# 0.001543f
C1020 SAR_validpin_0/DFFS_0/a_600_n400# SAR_validpin_0/DFFS_0/a_2550_720# 0.010754f
C1021 SAR_validpin_0/OR2_2/A SAR_validpin_0/DFFRR_1/a_n560_n400# 9.04e-20
C1022 SAR_validpin_0/DFFR_5/a_350_n430# SAR_validpin_0/DFFRR_0/a_2600_n430# 3.16e-20
C1023 SARclkgen_0/PHIB SAR_validpin_0/OR2_2/B 0.711812f
C1024 SARclkgen_0/PHIA SAR_validpin_0/DFFR_0/a_2090_n400# 0.533244f
C1025 CDAC_0/Vout CLK 0.288764f
C1026 Vin CDAC_0/Vout 5.921237f
C1027 SAR_validpin_0/OR2_1/A shift5to1v8_0/Y 0.812987f
C1028 SAR_validpin_0/DFFR_7/a_2090_n400# VALID 8.6e-19
C1029 SAR_validpin_0/OR2_0/B SAR_validpin_0/DFFR_1/a_2550_720# 6.08e-19
C1030 SAR_validpin_0/DFFR_5/a_2600_n430# SAR_validpin_0/DFFR_5/a_350_n430# 2.63e-19
C1031 strongarm_0/5v_pfet_1_1_0/D CDAC_0/b2 0.003905f
C1032 VDD_5V SAR_validpin_0/DFFR_7/a_2090_n400# 0.011702f
C1033 SAR_validpin_0/DFFR_3/a_n50_n400# SAR_validpin_0/AND2_1/Y 0.252806f
C1034 SARclkgen_0/PHIB SAR_validpin_0/DFFR_8/a_1310_n400# 0.005571f
C1035 SAR_validpin_0/DFFR_6/a_n50_n400# SAR_validpin_0/DFFR_6/a_90_n400# 0.538805f
C1036 SARclkgen_0/AND2_1/B SARclkgen_0/AND2_0/a_90_n200# 2.62e-19
C1037 SAR_validpin_0/DFFS_0/a_450_n400# SARclkgen_0/PHIA 0.799963f
C1038 SAR_validpin_0/DFFR_6/a_1130_520# VDD1v8 0.546664f
C1039 SAR_validpin_0/DFFR_4/a_450_n400# SAR_validpin_0/DFFR_4/a_1460_n400# 0.010382f
C1040 SRLatch5V_0/S CDAC_0/b3 2.52e-19
C1041 SAR_validpin_0/DFFR_6/a_350_n430# SAR_validpin_0/OR2_2/A 0.214058f
C1042 strongarm_0/clk SARclkgen_0/PHIB 0.017904f
C1043 VALID SAR_validpin_0/DFFR_7/a_n50_n400# 7e-19
C1044 VDD_5V SAR_validpin_0/DFFR_7/a_n50_n400# 0.009511f
C1045 SAR_validpin_0/DFFRR_1/D SAR_validpin_0/OR2_2/a_n80_n540# 0.00531f
C1046 SAR_validpin_0/DFFR_4/a_350_n430# SAR_validpin_0/DFFR_5/a_350_n430# 0.014677f
C1047 SARclkgen_0/AND2_1/B SARclkgen_0/AND2_0/B 0.341958f
C1048 SAR_validpin_0/OR2_0/B SAR_validpin_0/DFFR_3/a_1130_520# 0.00367f
C1049 shift5to1v8_0/Y SAR_validpin_0/DFFRR_1/a_n560_n400# 0.071056f
C1050 SAR_validpin_0/DFFR_0/a_n50_n400# SAR_validpin_0/DFFR_0/a_1460_n400# 0.006584f
C1051 CDAC_0/Vout shift1v8to5_1/5v_pfet_1_2_0/D 0.055195f
C1052 SAR_validpin_0/DFFRR_1/a_450_n400# SAR_validpin_0/OR2_0/a_n80_n540# 0.001583f
C1053 SAR_validpin_0/OR2_1/B SAR_validpin_0/DFFR_1/a_90_n400# 0.27475f
C1054 VDD_5V SAR_validpin_0/DFFR_0/a_2090_n400# 0.007411f
C1055 shift1v8to5_2/5v_pfet_1_2_0/D CDAC_0/b0 6.08e-19
C1056 SAR_validpin_0/AND2_1/a_n100_1100# SAR_validpin_0/DFFR_1/a_n50_n400# 0.004663f
C1057 SAR_validpin_0/DFFR_8/a_450_n400# VDD1v8 0.490511f
C1058 VDD1v8 SAR_validpin_0/DFFR_6/a_2090_n400# 0.904872f
C1059 shift1v8to5_1/A SAR_validpin_0/DFFR_3/a_350_n430# 0.007902f
C1060 VDD1v8 SAR_validpin_0/DFFR_7/a_2550_n400# 4.37e-19
C1061 shift1v8to5_1/A SAR_validpin_0/DFFR_5/a_n50_n400# 2.01e-20
C1062 shift1v8to5_5/5v_pfet_1_2_0/D RST_N 4.89e-20
C1063 shift1v8to5_1/A SAR_validpin_0/DFFR_0/a_1130_520# 0.034295f
C1064 shift1v8to5_2/A shift1v8to5_0/A 0.037544f
C1065 SAR_validpin_0/DFFR_3/a_450_n400# SAR_validpin_0/DFFR_4/a_1130_520# 9.74e-20
C1066 SAR_validpin_0/DFFR_8/a_1130_520# SAR_validpin_0/DFFR_8/a_n420_n400# 0.088465f
C1067 SARclkgen_0/PHIB SAR_validpin_0/DFFR_0/a_350_n430# 0.50589f
C1068 SAR_validpin_0/DFFR_4/a_n50_n400# SAR_validpin_0/DFFR_4/a_90_n400# 0.538805f
C1069 SAR_validpin_0/DFFR_6/a_1310_n400# VDD1v8 0.001032f
C1070 SAR_validpin_0/DFFR_6/a_1130_520# SAR_validpin_0/DFFR_5/a_1460_n400# 2.11e-19
C1071 SAR_validpin_0/DFFS_0/a_n50_n400# SARclkgen_0/PHIA 1.737942f
C1072 SAR_validpin_0/DFFR_7/a_2090_n400# SAR_validpin_0/OR2_2/A 0.251984f
C1073 VDD1v8 shift1v8to5_0/5v_pfet_1_2_2/D 0.425237f
C1074 shift1v8to5_2/A CDAC_0/b3 0.329205f
C1075 NOT5V_0/Y CDAC_0/SPDT_3/out 2.910524f
C1076 SAR_validpin_0/DFFS_0/a_600_n400# SAR_validpin_0/DFFR_8/a_n420_n400# 3.91e-20
C1077 shift1v8to5_0/A SAR_validpin_0/OR2_2/a_100_310# 0.014475f
C1078 SAR_validpin_0/DFFR_0/a_2550_720# SAR_validpin_0/DFFR_0/a_2090_n400# 0.011347f
C1079 SAR_validpin_0/DFFR_3/D SAR_validpin_0/AND2_1/a_n100_1100# 0.195456f
C1080 SAR_validpin_0/DFFR_2/a_2090_n400# SAR_validpin_0/DFFR_3/a_2090_n400# 0.009554f
C1081 VDD_5V SAR_validpin_0/DFFS_0/a_450_n400# 0.007351f
C1082 SAR_validpin_0/DFFR_1/a_350_n430# SAR_validpin_0/DFFR_0/a_2090_n400# 1.34e-19
C1083 VDD1v8 SAR_validpin_0/DFFR_7/a_450_n400# 0.477812f
C1084 SRLatch5V_0/S SARclkgen_0/PHIB 0.002593f
C1085 SAR_validpin_0/OR2_0/B SAR_validpin_0/AND2_1/Y 0.072224f
C1086 SAR_validpin_0/DFFR_6/a_1130_520# SAR_validpin_0/DFFR_5/a_450_n400# 9.74e-20
C1087 SAR_validpin_0/DFFS_0/a_350_n430# RST_N 0.71497f
C1088 RST_N SAR_validpin_0/DFFR_1/a_1130_520# 0.44098f
C1089 SARclkgen_0/PHIA SAR_validpin_0/DFFR_1/a_450_n400# 0.520494f
C1090 SAR_validpin_0/DFFS_0/a_n420_n400# NOT5V_0/Y 1.91e-19
C1091 SAR_validpin_0/DFFR_8/a_n50_n400# SAR_validpin_0/DFFR_8/a_2090_n400# 0.596659f
C1092 SAR_validpin_0/OR2_2/A SAR_validpin_0/DFFR_7/a_n50_n400# 0.182287f
C1093 SAR_validpin_0/DFFR_4/a_2090_n400# SAR_validpin_0/DFFR_4/a_1130_520# 1.24e-20
C1094 SAR_validpin_0/DFFRR_1/a_2600_n430# SAR_validpin_0/DFFRR_0/a_2090_n400# 4e-19
C1095 SAR_validpin_0/DFFR_7/a_n50_n400# SAR_validpin_0/2_1_MUX_2/a_n1230_n310# 2.47e-19
C1096 SAR_validpin_0/DFFS_0/a_2090_n400# SAR_validpin_0/DFFR_0/a_n420_n400# 0.130174f
C1097 SAR_validpin_0/DFFR_3/a_n420_n400# SAR_validpin_0/DFFR_3/a_1310_n400# 0.001016f
C1098 SRLatch5V_0/NQ SRLatch5V_0/NAND5v_1/5v_nfet_1_2_1/D 0.535718f
C1099 shift1v8to5_0/5v_pfet_1_2_0/D NOT5V_0/Y 0.002575f
C1100 SARclkgen_0/PHIB SAR_validpin_0/DFFS_0/a_2550_720# 0.003894f
C1101 SAR_validpin_0/AND2_1/a_n100_1100# VDD1v8 0.645808f
C1102 SAR_validpin_0/DFFR_4/a_350_n430# SAR_validpin_0/DFFR_4/a_1460_n400# 0.015634f
C1103 CDAC_0/Vcm SAR_validpin_0/DFFR_2/a_n420_n400# 0.001555f
C1104 SAR_validpin_0/DFFS_0/a_n50_n400# CLK5 2.71e-21
C1105 SAR_validpin_0/DFFS_0/a_90_n400# SAR_validpin_0/DFFR_8/a_2090_n400# 8.07e-19
C1106 SAR_validpin_0/DFFS_0/a_600_n400# SAR_validpin_0/DFFR_8/a_90_n400# 1.47e-20
C1107 SAR_validpin_0/DFFR_2/a_450_n400# SAR_validpin_0/DFFR_2/a_90_n400# 0.143349f
C1108 SAR_validpin_0/DFFRR_0/a_2600_n430# SAR_validpin_0/DFFRR_0/a_n560_n400# 0.101518f
C1109 SARclkgen_0/PHIB SAR_validpin_0/DFFRR_0/a_2600_n430# 4.47e-19
C1110 shift1v8to5_0/A SAR_validpin_0/DFFR_8/a_n420_n400# 0.021553f
C1111 SAR_validpin_0/DFFR_6/a_90_n400# SAR_validpin_0/DFFR_7/a_2600_n430# 2.37e-19
C1112 CDAC_0/b3 SRLatch5V_0/R 1.43e-19
C1113 SAR_validpin_0/DFFR_5/a_n420_n400# SAR_validpin_0/DFFR_5/a_1130_520# 0.088465f
C1114 SAR_validpin_0/DFFRR_0/a_n930_n400# SAR_validpin_0/DFFRR_0/a_2090_n400# 1.11e-20
C1115 shift1v8to5_3/5v_pfet_1_2_2/D SRLatch5V_0/Q 3.49e-19
C1116 SAR_validpin_0/DFFR_1/a_90_n400# SAR_validpin_0/OR2_0/a_n80_n540# 0.002627f
C1117 SAR_validpin_0/DFFR_6/a_n50_n400# SAR_validpin_0/DFFR_5/a_350_n430# 8.42e-20
C1118 SAR_validpin_0/DFFR_7/a_350_n430# SARclkgen_0/PHIA 0.071104f
C1119 SAR_validpin_0/DFFS_0/a_n50_n400# VDD_5V 0.009757f
C1120 shift1v8to5_1/A CLK 0.793364f
C1121 SAR_validpin_0/DFFR_7/a_450_n400# SAR_validpin_0/DFFR_7/a_90_n400# 0.143349f
C1122 SAR_validpin_0/DFFR_6/a_1130_520# SAR_validpin_0/AND2_1/Y 0.115688f
C1123 VDD1v8 SAR_validpin_0/DFFR_3/a_2090_n400# 0.918708f
C1124 SAR_validpin_0/OR2_1/B SAR_validpin_0/DFFR_0/a_3210_n400# 0.006676f
C1125 shift1v8to5_1/A Vin 0.085902f
C1126 RST_N SAR_validpin_0/OR2_2/a_n80_n540# 2.39e-20
C1127 SARclkgen_0/PHIB shift1v8to5_2/A 0.160821f
C1128 SAR_validpin_0/DFFR_4/a_n50_n400# SAR_validpin_0/DFFRR_1/a_3210_n400# 2.41e-19
C1129 SAR_validpin_0/DFFR_2/a_n50_n400# SAR_validpin_0/DFFR_2/a_1130_520# 0.003341f
C1130 SAR_validpin_0/DFFR_2/a_450_n400# SAR_validpin_0/DFFR_2/a_350_n430# 0.980343f
C1131 CLK5 SAR_validpin_0/DFFR_1/a_450_n400# 2.51e-20
C1132 SAR_validpin_0/DFFR_2/a_2550_n400# SAR_validpin_0/DFFR_2/a_2090_n400# 0.006257f
C1133 SAR_validpin_0/OR2_2/B NOT5V_0/Y 8.98e-19
C1134 SAR_validpin_0/DFFRR_0/a_350_n430# SAR_validpin_0/DFFR_7/a_350_n430# 0.019353f
C1135 SAR_validpin_0/DFFRR_0/a_n930_n400# SAR_validpin_0/DFFR_7/a_1130_520# 3.28e-20
C1136 SAR_validpin_0/OR2_2/B SAR_validpin_0/DFFR_7/a_n420_n400# 0.003052f
C1137 shift5to1v8_0/Y SAR_validpin_0/DFFR_7/a_n50_n400# 0.006884f
C1138 SAR_validpin_0/OR2_1/B SAR_validpin_0/DFFRR_0/D 0.428175f
C1139 VDD_5V SAR_validpin_0/DFFR_1/a_450_n400# 0.013202f
C1140 VDD1v8 SARclkgen_0/AND2_0/a_90_n200# 7.31e-19
C1141 shift1v8to5_1/A SAR_validpin_0/OR2_1/a_100_310# 8.16e-19
C1142 SAR_validpin_0/DFFR_8/a_90_n400# shift1v8to5_0/A 0.007373f
C1143 SAR_validpin_0/DFFR_2/a_n50_n400# SAR_validpin_0/DFFR_2/a_1310_n400# 0.006175f
C1144 SAR_validpin_0/AND2_1/Y SAR_validpin_0/DFFR_6/a_2090_n400# 2.44e-19
C1145 SARclkgen_0/AND2_0/B VDD1v8 0.475796f
C1146 shift1v8to5_1/A SAR_validpin_0/DFFR_8/a_2550_720# 1.88e-19
C1147 CDAC_0/Vout CDAC_0/SPDT_3/out 2.181783f
C1148 SAR_validpin_0/DFFR_2/a_1460_n400# shift1v8to5_1/A 2.42e-19
C1149 SAR_validpin_0/DFFR_6/a_1310_n400# SAR_validpin_0/AND2_1/Y 0.005794f
C1150 shift1v8to5_1/A shift1v8to5_1/5v_pfet_1_2_0/D 0.459813f
C1151 VDD_5V SAR_validpin_0/DFFR_2/a_2550_720# 8.67e-19
C1152 strongarm_0/clk NOT5V_0/Y 3.386096f
C1153 SAR_validpin_0/DFFR_0/a_2600_n430# SAR_validpin_0/DFFR_1/a_90_n400# 2.37e-19
C1154 SAR_validpin_0/OR2_1/B shift1v8to5_0/A 0.16779f
C1155 SAR_validpin_0/DFFR_1/a_350_n430# SAR_validpin_0/DFFR_1/a_450_n400# 0.980343f
C1156 CDAC_0/Vcm CDAC_0/b3 2.535861f
C1157 SARclkgen_0/PHIB SRLatch5V_0/R 0.01836f
C1158 SAR_validpin_0/DFFR_7/a_350_n430# VALID 0.001114f
C1159 SAR_validpin_0/DFFR_3/a_n420_n400# SAR_validpin_0/DFFR_2/a_n420_n400# 0.004656f
C1160 VDD_5V SAR_validpin_0/DFFR_7/a_350_n430# 0.0182f
C1161 SAR_validpin_0/OR2_0/B SAR_validpin_0/DFFRR_1/a_2090_n400# 7.37e-20
C1162 shift5to1v8_0/5v_pfet_1_2_1/G SARclkgen_0/PHIA 0.001057f
C1163 SARclkgen_0/PHIB SAR_validpin_0/DFFR_8/a_n420_n400# 0.780456f
C1164 shift1v8to5_1/A SAR_validpin_0/DFFR_8/a_350_n430# 0.249039f
C1165 SAR_validpin_0/DFFR_3/a_1130_520# SAR_validpin_0/DFFR_3/a_2090_n400# 1.24e-20
C1166 SRLatch5V_0/NQ shift1v8to5_3/A 8.7e-19
C1167 SAR_validpin_0/OR2_0/B SAR_validpin_0/DFFRR_1/a_1460_n400# 1.84e-19
C1168 RST_N SAR_validpin_0/DFFR_3/a_350_n430# 0.211779f
C1169 SAR_validpin_0/DFFS_0/a_n420_n400# CDAC_0/Vout 0.008313f
C1170 SAR_validpin_0/DFFR_4/a_2600_n430# ADC_OUT1 0.770202f
C1171 RST_N SAR_validpin_0/DFFR_5/a_n50_n400# 0.174567f
C1172 RST_N SAR_validpin_0/DFFR_0/a_1130_520# 0.44098f
C1173 shift1v8to5_0/5v_pfet_1_2_0/D CDAC_0/Vout 0.060528f
C1174 VDD1v8 SAR_validpin_0/DFFS_0/a_2090_n400# 1.054726f
C1175 SAR_validpin_0/DFFR_5/a_2600_n430# ADC_OUT2 0.770815f
C1176 SAR_validpin_0/DFFR_0/a_1460_n400# SAR_validpin_0/DFFR_0/a_n420_n400# 0.001621f
C1177 SAR_validpin_0/DFFR_0/a_350_n430# NOT5V_0/Y 2.03e-19
C1178 SAR_validpin_0/DFFR_0/a_90_n400# CDAC_0/SPDT_3/out 0.002185f
C1179 SAR_validpin_0/AND2_1/a_n100_1100# SAR_validpin_0/AND2_1/Y 0.294557f
C1180 SAR_validpin_0/DFFR_0/a_n50_n400# SAR_validpin_0/DFFR_0/a_2090_n400# 0.596781f
C1181 SAR_validpin_0/DFFR_3/a_90_n400# SARclkgen_0/PHIA 2.55e-19
C1182 SAR_validpin_0/DFFRR_1/a_1130_520# SAR_validpin_0/DFFRR_0/a_1130_520# 0.009107f
C1183 VDD1v8 SAR_validpin_0/DFFRR_0/a_2090_n400# 0.931311f
C1184 shift1v8to5_2/5v_pfet_1_2_2/D VDD1v8 0.633901f
C1185 SAR_validpin_0/DFFS_0/a_350_n430# SAR_validpin_0/DFFR_8/a_2600_n430# 0.001482f
C1186 SAR_validpin_0/2_1_MUX_0/a_n1230_n310# SAR_validpin_0/OR2_1/a_n80_n540# 0.0015f
C1187 SAR_validpin_0/2_1_MUX_0/a_n1230_n310# shift1v8to5_3/A 5.17e-20
C1188 SAR_validpin_0/AND2_2/a_n100_1100# SAR_validpin_0/DFFRR_1/a_n560_n400# 2.04e-19
C1189 SARclkgen_0/PHIB SAR_validpin_0/DFFR_8/a_90_n400# 0.578702f
C1190 SAR_validpin_0/AND2_0/Y SAR_validpin_0/DFFR_3/a_90_n400# 0.07007f
C1191 shift1v8to5_0/5v_pfet_1_2_2/D CDAC_0/b2 0.026692f
C1192 SAR_validpin_0/DFFRR_0/a_n930_n400# SAR_validpin_0/OR2_1/A 0.066459f
C1193 SAR_validpin_0/DFFR_5/a_2090_n400# VDD1v8 0.915455f
C1194 SRLatch5V_0/S NOT5V_0/Y 0.003595f
C1195 SAR_validpin_0/DFFR_0/a_90_n400# shift1v8to5_3/A 4.86e-20
C1196 SAR_validpin_0/DFFR_7/a_1130_520# VDD1v8 0.540239f
C1197 SAR_validpin_0/DFFS_0/a_2550_n400# CDAC_0/SPDT_3/out 1.53e-19
C1198 shift1v8to5_4/5v_pfet_1_2_2/D SARclkgen_0/PHIB 0.004518f
C1199 SAR_validpin_0/DFFR_0/a_n50_n400# SAR_validpin_0/DFFS_0/a_450_n400# 1.28e-19
C1200 SAR_validpin_0/DFFR_2/a_n50_n400# SARclkgen_0/PHIA 1.873086f
C1201 SAR_validpin_0/AND2_1/Y SAR_validpin_0/DFFR_3/a_2090_n400# 2.44e-19
C1202 SAR_validpin_0/DFFRR_1/a_1130_520# SAR_validpin_0/DFFRR_1/a_n930_n400# 0.088454f
C1203 SAR_validpin_0/DFFRR_1/a_n560_n400# SAR_validpin_0/DFFRR_1/a_n420_720# 0.252522f
C1204 SAR_validpin_0/OR2_2/B CDAC_0/Vout 0.00658f
C1205 SARclkgen_0/PHIB CDAC_0/Vcm 7.13e-19
C1206 SAR_validpin_0/DFFR_6/a_450_n400# shift1v8to5_1/A 4.67e-19
C1207 SAR_validpin_0/DFFR_7/a_350_n430# SAR_validpin_0/OR2_2/A 0.080911f
C1208 SAR_validpin_0/DFFR_7/a_350_n430# SAR_validpin_0/2_1_MUX_2/a_n1230_n310# 1.86e-19
C1209 SAR_validpin_0/DFFR_7/D SARclkgen_0/PHIA 0.148501f
C1210 SAR_validpin_0/DFFRR_1/a_2600_n430# SAR_validpin_0/DFFRR_1/a_n560_n400# 0.101518f
C1211 shift5to1v8_0/5v_pfet_1_2_1/G VDD_5V 0.077822f
C1212 SAR_validpin_0/OR2_1/B SAR_validpin_0/DFFRR_0/a_n560_n400# 0.001255f
C1213 SARclkgen_0/PHIB SAR_validpin_0/OR2_1/B 1.015237f
C1214 SAR_validpin_0/DFFRR_0/a_1310_n400# SAR_validpin_0/DFFRR_0/a_450_n400# 0.014507f
C1215 SAR_validpin_0/DFFR_0/a_3210_n400# SAR_validpin_0/DFFR_0/a_2600_n430# 0.011304f
C1216 shift1v8to5_0/A SAR_validpin_0/OR2_0/a_n80_n540# 0.393011f
C1217 SARclkgen_0/PHIA shift1v8to5_4/5v_pfet_1_2_0/D 0.058754f
C1218 SAR_validpin_0/DFFR_6/a_1460_n400# VDD1v8 9.65e-19
C1219 SARclkgen_0/PHIB SAR_validpin_0/DFFRR_1/a_1130_520# 0.115688f
C1220 CDAC_0/b0 shift1v8to5_0/A 0.021414f
C1221 strongarm_0/5v_nfet_1_1_3/S CDAC_0/Vout 0.310002f
C1222 shift5to1v8_0/5v_pfet_1_2_1/G SRLatch5V_0/NAND5v_0/5v_nfet_1_2_1/D 3.91e-20
C1223 RST_N CLK 0.750905f
C1224 SAR_validpin_0/2_1_MUX_0/a_n1230_n310# SAR_validpin_0/OR2_2/B 0.011924f
C1225 ADC_OUT3 SAR_validpin_0/DFFR_6/a_2600_n430# 0.769552f
C1226 RST_N Vin 0.094987f
C1227 shift1v8to5_1/5v_pfet_1_2_2/D shift1v8to5_2/A 0.043401f
C1228 SRLatch5V_0/NQ strongarm_0/clk 2.59e-19
C1229 CDAC_0/b0 CDAC_0/b3 0.73731f
C1230 strongarm_0/clk CDAC_0/Vout 0.141819f
C1231 SAR_validpin_0/OR2_2/B SAR_validpin_0/DFFR_0/a_90_n400# 0.391855f
C1232 SAR_validpin_0/DFFR_5/a_450_n400# SAR_validpin_0/DFFRR_0/a_2090_n400# 2.95e-20
C1233 SAR_validpin_0/DFFR_1/a_1310_n400# SAR_validpin_0/DFFR_1/a_450_n400# 0.014507f
C1234 SARclkgen_0/PHIA SAR_validpin_0/DFFR_4/a_n420_n400# 1.79e-19
C1235 SAR_validpin_0/DFFR_7/a_350_n430# shift5to1v8_0/Y 0.004405f
C1236 SAR_validpin_0/AND2_0/Y SAR_validpin_0/DFFR_4/a_n420_n400# 0.153904f
C1237 RST_N SAR_validpin_0/DFFR_4/a_1130_520# 0.430407f
C1238 SAR_validpin_0/DFFR_2/a_n50_n400# VDD_5V 0.009518f
C1239 SRLatch5V_0/Q CDAC_0/b3 7.84e-20
C1240 SAR_validpin_0/DFFR_5/a_2090_n400# SAR_validpin_0/DFFR_5/a_450_n400# 0.28571f
C1241 SAR_validpin_0/DFFR_2/a_450_n400# SAR_validpin_0/DFFR_2/a_2090_n400# 0.28571f
C1242 SAR_validpin_0/DFFR_7/D VALID 0.005647f
C1243 SAR_validpin_0/OR2_0/A SAR_validpin_0/OR2_1/a_n80_n540# 6.07e-19
C1244 SAR_validpin_0/OR2_0/A shift1v8to5_3/A 0.022569f
C1245 SAR_validpin_0/DFFRR_1/a_n930_n400# SAR_validpin_0/OR2_0/a_n80_n540# 3.05e-20
C1246 SAR_validpin_0/2_1_MUX_1/a_n1230_n310# SAR_validpin_0/DFFRR_0/a_450_n400# 2.6e-21
C1247 CLK5 shift1v8to5_4/5v_pfet_1_2_0/D 2.32e-19
C1248 SAR_validpin_0/DFFR_7/D VDD_5V 0.012275f
C1249 shift1v8to5_0/A SAR_validpin_0/DFFR_0/a_2600_n430# 2.65e-19
C1250 SAR_validpin_0/OR2_0/a_100_310# shift1v8to5_0/A 0.018292f
C1251 SAR_validpin_0/DFFR_0/a_350_n430# CDAC_0/Vout 0.007751f
C1252 SAR_validpin_0/OR2_0/B SAR_validpin_0/DFFR_1/a_1130_520# 0.00296f
C1253 SAR_validpin_0/AND2_1/a_n100_1100# SAR_validpin_0/DFFRR_1/a_2090_n400# 0.006969f
C1254 RST_N SAR_validpin_0/DFFR_8/a_2550_720# 0.013514f
C1255 SAR_validpin_0/DFFR_2/a_1460_n400# RST_N 0.002765f
C1256 SAR_validpin_0/DFFR_3/a_n420_n400# SARclkgen_0/PHIB 8.93e-20
C1257 SAR_validpin_0/DFFR_3/a_450_n400# SAR_validpin_0/DFFR_3/a_2600_n430# 0.002434f
C1258 VDD_5V shift1v8to5_4/5v_pfet_1_2_0/D 0.309703f
C1259 SAR_validpin_0/DFFS_0/a_1460_n400# CDAC_0/SPDT_3/out 7.14e-20
C1260 SAR_validpin_0/AND2_1/Y SAR_validpin_0/DFFRR_0/a_2090_n400# 0.005465f
C1261 shift1v8to5_1/A SAR_validpin_0/OR2_1/a_n80_n540# 0.001448f
C1262 shift1v8to5_1/A shift1v8to5_3/A 9.66e-19
C1263 SARclkgen_0/PHIB SAR_validpin_0/OR2_0/a_n80_n540# 5.84e-20
C1264 SAR_validpin_0/DFFS_0/a_n420_n400# shift1v8to5_1/A 0.202389f
C1265 SAR_validpin_0/OR2_1/A VDD1v8 1.321689f
C1266 NOT5V_0/Y SRLatch5V_0/R 0.007569f
C1267 shift1v8to5_1/A SAR_validpin_0/DFFR_6/a_2600_n430# 0.003432f
C1268 CDAC_0/SPDT_0/out CLK5 2.617763f
C1269 RST_N SAR_validpin_0/DFFR_8/a_350_n430# 0.212378f
C1270 SRLatch5V_0/S SRLatch5V_0/NQ 0.975408f
C1271 SRLatch5V_0/S CDAC_0/Vout 0.026644f
C1272 SARclkgen_0/PHIB SAR_validpin_0/DFFR_7/a_2600_n430# 4.47e-19
C1273 SAR_validpin_0/DFFR_5/a_2090_n400# SAR_validpin_0/AND2_1/Y 2.44e-19
C1274 SAR_validpin_0/DFFR_5/a_2550_720# SAR_validpin_0/DFFR_5/a_2090_n400# 0.011347f
C1275 SAR_validpin_0/DFFR_4/a_2600_n430# SAR_validpin_0/DFFR_4/a_3210_n400# 0.011304f
C1276 SAR_validpin_0/DFFR_3/a_n50_n400# SAR_validpin_0/DFFR_3/a_350_n430# 0.260805f
C1277 SAR_validpin_0/OR2_1/A SAR_validpin_0/DFFRR_0/a_3210_n400# 0.006839f
C1278 SAR_validpin_0/DFFR_3/D SAR_validpin_0/DFFRR_1/a_n560_n400# 0.005059f
C1279 SAR_validpin_0/DFFS_0/a_n420_n400# SAR_validpin_0/DFFS_0/a_1460_n400# 0.001091f
C1280 CDAC_0/SPDT_0/out VDD_5V 1.622596f
C1281 SAR_validpin_0/DFFR_4/a_2090_n400# SAR_validpin_0/DFFR_3/a_2600_n430# 3.11e-20
C1282 SAR_validpin_0/DFFR_4/a_2600_n430# SAR_validpin_0/DFFR_3/a_2090_n400# 3.11e-20
C1283 SAR_validpin_0/DFFR_0/a_350_n430# SAR_validpin_0/DFFR_0/a_90_n400# 0.349264f
C1284 shift5to1v8_0/5v_pfet_1_2_1/G shift5to1v8_0/Y 0.543891f
C1285 SAR_validpin_0/OR2_0/A SAR_validpin_0/OR2_2/B 0.23265f
C1286 SAR_validpin_0/DFFR_2/a_450_n400# VDD1v8 0.518729f
C1287 SAR_validpin_0/OR2_0/B SAR_validpin_0/OR2_2/a_n80_n540# 0.01035f
C1288 SARclkgen_0/PHIA SAR_validpin_0/DFFRR_1/a_2550_n400# 0.001071f
C1289 NOT5V_0/Y SAR_validpin_0/DFFR_0/a_2550_n400# 4.44e-20
C1290 SARclkgen_0/PHIB SRLatch5V_0/Q 0.027785f
C1291 SAR_validpin_0/AND2_0/Y SAR_validpin_0/DFFRR_1/a_2550_n400# 2.18e-19
C1292 SAR_validpin_0/AND2_0/Y SAR_validpin_0/DFFR_3/a_1460_n400# 0.00384f
C1293 strongarm_0/5v_pfet_1_1_0/D CLK 0.002873f
C1294 SAR_validpin_0/DFFR_4/a_450_n400# SAR_validpin_0/DFFR_3/a_450_n400# 0.018533f
C1295 SAR_validpin_0/DFFR_7/D SAR_validpin_0/OR2_2/A 0.468409f
C1296 SAR_validpin_0/DFFRR_0/a_n930_n400# SAR_validpin_0/DFFR_7/a_n50_n400# 2.54e-20
C1297 VDD1v8 SAR_validpin_0/DFFRR_1/a_n560_n400# 0.452325f
C1298 SAR_validpin_0/DFFR_7/D SAR_validpin_0/2_1_MUX_2/a_n1230_n310# 1.140899f
C1299 CDAC_0/Vcm SAR_validpin_0/DFFR_1/a_2600_n430# 0.003089f
C1300 SAR_validpin_0/DFFR_2/a_2600_n430# SAR_validpin_0/DFFR_3/a_2600_n430# 0.010329f
C1301 SAR_validpin_0/DFFRR_1/D shift1v8to5_3/A 1.41e-20
C1302 SAR_validpin_0/DFFRR_1/D SAR_validpin_0/OR2_1/a_n80_n540# 0.002461f
C1303 SAR_validpin_0/OR2_1/A SAR_validpin_0/DFFR_7/a_90_n400# 0.002636f
C1304 SAR_validpin_0/DFFR_6/a_1460_n400# SAR_validpin_0/AND2_1/Y 0.009764f
C1305 SAR_validpin_0/DFFRR_1/a_450_n400# SAR_validpin_0/DFFRR_1/a_n340_n430# 0.059006f
C1306 shift1v8to5_2/5v_pfet_1_2_2/D CDAC_0/b2 0.879918f
C1307 SRLatch5V_0/NQ shift1v8to5_2/A 0.159598f
C1308 shift1v8to5_1/A SAR_validpin_0/OR2_2/B 0.276536f
C1309 RST_N SAR_validpin_0/DFFRR_0/a_2550_n400# 7.85e-19
C1310 SAR_validpin_0/DFFR_0/a_n420_n400# SAR_validpin_0/DFFR_0/a_2090_n400# 1.11e-20
C1311 shift1v8to5_2/A CDAC_0/Vout 0.212593f
C1312 SARclkgen_0/PHIB SAR_validpin_0/DFFR_0/a_2600_n430# 0.105132f
C1313 shift1v8to5_4/5v_pfet_1_2_2/D NOT5V_0/Y 0.015328f
C1314 SAR_validpin_0/DFFR_8/a_450_n400# SAR_validpin_0/DFFS_0/a_350_n430# 5.82e-20
C1315 SAR_validpin_0/DFFR_6/a_450_n400# RST_N 0.303422f
C1316 CDAC_0/Vcm NOT5V_0/Y 1.858967f
C1317 SAR_validpin_0/DFFR_2/a_1130_520# SAR_validpin_0/DFFR_2/a_1310_n400# 0.002821f
C1318 SAR_validpin_0/OR2_1/A SAR_validpin_0/DFFR_5/a_450_n400# 0.049414f
C1319 shift1v8to5_1/A SAR_validpin_0/DFFR_8/a_1310_n400# 1.61e-19
C1320 SAR_validpin_0/DFFR_4/a_2090_n400# SAR_validpin_0/DFFR_4/a_450_n400# 0.28571f
C1321 SAR_validpin_0/OR2_1/B NOT5V_0/Y 1.76e-19
C1322 SARclkgen_0/PHIA SARclkgen_0/AND2_0/A 0.14385f
C1323 SAR_validpin_0/DFFRR_1/a_450_n400# SAR_validpin_0/DFFRR_0/a_450_n400# 0.010201f
C1324 SAR_validpin_0/DFFS_0/a_450_n400# SAR_validpin_0/DFFR_0/a_n420_n400# 8.6e-19
C1325 SAR_validpin_0/DFFR_6/a_350_n430# VDD1v8 1.250311f
C1326 SAR_validpin_0/DFFR_4/a_n50_n400# SAR_validpin_0/DFFR_4/a_1460_n400# 0.006584f
C1327 strongarm_0/clk shift1v8to5_1/A 0.120063f
C1328 shift1v8to5_1/A SAR_validpin_0/DFFR_3/a_2600_n430# 0.007837f
C1329 SAR_validpin_0/DFFR_2/a_450_n400# SAR_validpin_0/DFFR_3/a_1130_520# 3.51e-19
C1330 SAR_validpin_0/2_1_MUX_0/a_n1230_n310# shift1v8to5_2/A 0.002064f
C1331 SAR_validpin_0/DFFR_7/D shift5to1v8_0/Y 0.78577f
C1332 CDAC_0/Vcm SAR_validpin_0/DFFR_1/a_2090_n400# 5.35e-19
C1333 shift1v8to5_2/A SAR_validpin_0/DFFR_0/a_90_n400# 7.9e-20
C1334 SAR_validpin_0/OR2_0/B SAR_validpin_0/DFFR_3/a_350_n430# 0.027907f
C1335 SAR_validpin_0/DFFR_3/a_n420_n400# SAR_validpin_0/AND2_0/a_n100_1100# 0.015618f
C1336 SAR_validpin_0/DFFRR_1/D SAR_validpin_0/OR2_2/B 0.022435f
C1337 SAR_validpin_0/DFFR_0/a_450_n400# SARclkgen_0/PHIA 0.51658f
C1338 shift1v8to5_0/5v_pfet_1_2_2/D shift1v8to5_3/5v_pfet_1_2_0/D 9.68e-19
C1339 SAR_validpin_0/DFFS_0/a_3210_n400# SAR_validpin_0/DFFS_0/a_2090_n400# 0.011304f
C1340 SAR_validpin_0/DFFR_8/a_n50_n400# SAR_validpin_0/DFFR_8/a_1130_520# 0.003341f
C1341 shift5to1v8_0/Y shift1v8to5_4/5v_pfet_1_2_0/D 2.11e-19
C1342 SAR_validpin_0/DFFRR_0/a_2090_n400# SAR_validpin_0/DFFRR_1/a_2090_n400# 0.008351f
C1343 SRLatch5V_0/NQ SRLatch5V_0/R 1.880344f
C1344 SRLatch5V_0/R CDAC_0/Vout 0.34188f
C1345 SAR_validpin_0/DFFR_1/a_n50_n400# SAR_validpin_0/DFFR_0/a_2090_n400# 4.83e-19
C1346 SAR_validpin_0/DFFR_4/a_450_n400# SAR_validpin_0/OR2_0/A 0.04952f
C1347 SAR_validpin_0/OR2_1/A SAR_validpin_0/AND2_1/Y 0.416599f
C1348 shift1v8to5_1/A SAR_validpin_0/DFFR_0/a_350_n430# 0.068356f
C1349 SAR_validpin_0/DFFR_8/a_n50_n400# SAR_validpin_0/DFFS_0/a_600_n400# 7.32e-20
C1350 SAR_validpin_0/AND2_2/a_n100_1100# SAR_validpin_0/DFFR_1/a_450_n400# 0.003928f
C1351 SAR_validpin_0/DFFR_3/a_n50_n400# SAR_validpin_0/DFFR_4/a_1130_520# 3.29e-20
C1352 SAR_validpin_0/DFFR_3/a_450_n400# SAR_validpin_0/DFFR_4/a_350_n430# 4.59e-20
C1353 SAR_validpin_0/DFFR_7/a_2090_n400# VDD1v8 0.920855f
C1354 RST_N CDAC_0/SPDT_3/out 0.001755f
C1355 SAR_validpin_0/DFFS_0/a_1130_520# SARclkgen_0/PHIA 0.120817f
C1356 SAR_validpin_0/DFFR_5/a_1130_520# SAR_validpin_0/DFFR_5/a_350_n430# 0.24593f
C1357 CLK5 SARclkgen_0/AND2_0/A 1.81e-19
C1358 SAR_validpin_0/DFFR_4/a_2600_n430# SAR_validpin_0/DFFR_5/a_2090_n400# 4e-19
C1359 SAR_validpin_0/DFFR_4/a_2090_n400# SAR_validpin_0/DFFR_5/a_2600_n430# 4e-19
C1360 SAR_validpin_0/DFFR_6/a_n420_n400# SARclkgen_0/PHIA 1.79e-19
C1361 SAR_validpin_0/DFFS_0/a_90_n400# SAR_validpin_0/DFFS_0/a_600_n400# 0.306481f
C1362 SAR_validpin_0/DFFR_0/a_2550_n400# CDAC_0/Vout 9.77e-19
C1363 VDD_5V SARclkgen_0/AND2_0/A 0.073261f
C1364 SAR_validpin_0/DFFR_1/a_n420_n400# SAR_validpin_0/DFFR_0/a_2090_n400# 0.010629f
C1365 SAR_validpin_0/AND2_0/Y SAR_validpin_0/DFFR_6/a_n420_n400# 0.086836f
C1366 SRLatch5V_0/S shift1v8to5_1/A 0.003376f
C1367 SAR_validpin_0/DFFS_0/a_n420_n400# RST_N 0.342373f
C1368 VDD1v8 SAR_validpin_0/DFFR_7/a_n50_n400# 0.43181f
C1369 RST_N SAR_validpin_0/OR2_1/a_n80_n540# 4.97e-19
C1370 RST_N shift1v8to5_3/A 7.09e-19
C1371 SAR_validpin_0/DFFR_6/a_350_n430# SAR_validpin_0/DFFR_5/a_450_n400# 4.59e-20
C1372 SAR_validpin_0/DFFR_6/a_1130_520# SAR_validpin_0/DFFR_5/a_n50_n400# 3.29e-20
C1373 SAR_validpin_0/DFFR_8/a_2600_n430# SAR_validpin_0/DFFR_8/a_350_n430# 2.63e-19
C1374 RST_N SAR_validpin_0/DFFR_6/a_2600_n430# 0.575636f
C1375 SAR_validpin_0/DFFR_3/a_90_n400# SAR_validpin_0/DFFR_2/a_90_n400# 0.004811f
C1376 SAR_validpin_0/AND2_1/Y SAR_validpin_0/DFFRR_1/a_n560_n400# 0.007152f
C1377 SAR_validpin_0/DFFR_8/a_1130_520# SAR_validpin_0/DFFR_8/a_2090_n400# 1.24e-20
C1378 SAR_validpin_0/DFFR_4/a_2090_n400# SAR_validpin_0/DFFR_4/a_350_n430# 0.001602f
C1379 SAR_validpin_0/DFFR_2/a_1130_520# SARclkgen_0/PHIA 2.36e-19
C1380 SAR_validpin_0/DFFR_0/a_450_n400# VDD_5V 0.007109f
C1381 shift1v8to5_4/5v_pfet_1_2_2/D SRLatch5V_0/NQ 0.002669f
C1382 SAR_validpin_0/DFFR_8/a_n50_n400# shift1v8to5_0/A 0.013837f
C1383 SAR_validpin_0/DFFR_7/a_2600_n430# SAR_validpin_0/DFFR_7/a_n420_n400# 4.26e-20
C1384 VDD1v8 SAR_validpin_0/DFFR_0/a_2090_n400# 0.92089f
C1385 CDAC_0/b0 shift1v8to5_1/5v_pfet_1_2_2/D 1.296695f
C1386 CDAC_0/b0 NOT5V_0/Y 4.21843f
C1387 shift1v8to5_1/A SAR_validpin_0/DFFS_0/a_2550_720# 0.006928f
C1388 SARclkgen_0/AND2_0/a_n100_1100# CLK 0.217257f
C1389 CDAC_0/Vcm CDAC_0/Vout 21.474672f
C1390 SAR_validpin_0/DFFR_3/a_90_n400# SAR_validpin_0/DFFR_2/a_350_n430# 6.99e-20
C1391 SAR_validpin_0/OR2_0/A shift1v8to5_2/A 0.00393f
C1392 SAR_validpin_0/DFFS_0/a_600_n400# SAR_validpin_0/DFFR_8/a_2090_n400# 0.001948f
C1393 SAR_validpin_0/DFFR_2/a_n50_n400# SAR_validpin_0/DFFR_2/a_90_n400# 0.538805f
C1394 SARclkgen_0/PHIA SAR_validpin_0/DFFR_2/a_1310_n400# 0.003587f
C1395 SAR_validpin_0/OR2_1/B CDAC_0/Vout 0.006215f
C1396 SAR_validpin_0/DFFR_5/a_n420_n400# SAR_validpin_0/DFFR_5/a_350_n430# 0.316282f
C1397 SAR_validpin_0/DFFS_0/a_1130_520# VDD_5V 0.001539f
C1398 SAR_validpin_0/DFFR_7/a_n50_n400# SAR_validpin_0/DFFR_7/a_90_n400# 0.538805f
C1399 SAR_validpin_0/DFFR_5/a_2600_n430# shift1v8to5_1/A 0.002645f
C1400 SAR_validpin_0/DFFR_6/a_n420_n400# VALID 4.93e-19
C1401 SAR_validpin_0/DFFR_7/a_450_n400# SAR_validpin_0/DFFR_7/a_1460_n400# 0.010382f
C1402 SAR_validpin_0/DFFR_6/a_350_n430# SAR_validpin_0/AND2_1/Y 0.474818f
C1403 SAR_validpin_0/OR2_0/A SAR_validpin_0/DFFR_4/a_350_n430# 0.214204f
C1404 SAR_validpin_0/DFFR_2/a_n50_n400# SAR_validpin_0/DFFR_2/a_350_n430# 0.260805f
C1405 CLK_comp CDAC_0/b3 0.020262f
C1406 SAR_validpin_0/DFFR_6/a_n420_n400# VDD_5V 0.009156f
C1407 shift1v8to5_1/A shift1v8to5_2/A 0.013355f
C1408 SAR_validpin_0/OR2_0/B SAR_validpin_0/OR2_1/a_100_310# 6.13e-19
C1409 SAR_validpin_0/DFFR_6/a_1130_520# SAR_validpin_0/DFFR_5/a_1310_n400# 2.11e-19
C1410 SAR_validpin_0/DFFS_0/a_450_n400# VDD1v8 0.648891f
C1411 RST_N SAR_validpin_0/OR2_2/B 0.238019f
C1412 SAR_validpin_0/DFFS_0/a_450_n400# SAR_validpin_0/DFFS_0/a_1310_n400# 0.019473f
C1413 RST_N SAR_validpin_0/DFFR_8/a_3210_n400# 0.001947f
C1414 NOT5V_0/Y SAR_validpin_0/DFFR_0/a_2600_n430# 4.02e-19
C1415 VDD_5V SAR_validpin_0/DFFR_2/a_1130_520# 1.22e-19
C1416 shift1v8to5_1/A SAR_validpin_0/OR2_2/a_100_310# 8.16e-19
C1417 SAR_validpin_0/DFFR_8/a_2090_n400# shift1v8to5_0/A 0.014712f
C1418 SAR_validpin_0/2_1_MUX_0/a_n1230_n310# SAR_validpin_0/OR2_1/B 0.153612f
C1419 SAR_validpin_0/AND2_0/Y SAR_validpin_0/DFFR_5/a_90_n400# 0.102842f
C1420 SAR_validpin_0/DFFR_1/a_450_n400# SAR_validpin_0/DFFR_1/a_n50_n400# 0.81908f
C1421 CDAC_0/SPDT_0/out CDAC_0/b1 1.062649f
C1422 SAR_validpin_0/DFFR_0/a_450_n400# SAR_validpin_0/OR2_2/A 7.08e-19
C1423 SAR_validpin_0/DFFR_2/a_1460_n400# SAR_validpin_0/OR2_0/B 1.21e-19
C1424 SAR_validpin_0/DFFS_0/a_350_n430# SAR_validpin_0/DFFS_0/a_2090_n400# 0.287931f
C1425 SAR_validpin_0/DFFR_7/a_2090_n400# SAR_validpin_0/AND2_1/Y 0.005277f
C1426 RST_N SAR_validpin_0/DFFR_3/a_2600_n430# 0.624455f
C1427 strongarm_0/clk RST_N 0.325576f
C1428 SAR_validpin_0/DFFR_4/a_90_n400# SAR_validpin_0/DFFR_5/a_350_n430# 6.99e-20
C1429 strongarm_0/5v_pfet_1_1_3/D CDAC_0/b3 4.21e-19
C1430 SAR_validpin_0/DFFR_3/D SAR_validpin_0/DFFR_1/a_450_n400# 3.81e-19
C1431 SAR_validpin_0/DFFRR_1/D shift1v8to5_2/A 3.92e-20
C1432 SAR_validpin_0/DFFR_8/a_n50_n400# SARclkgen_0/PHIB 0.237704f
C1433 SAR_validpin_0/DFFR_2/a_2550_720# SAR_validpin_0/DFFR_2/a_2090_n400# 0.011347f
C1434 SAR_validpin_0/DFFS_0/a_n50_n400# SAR_validpin_0/DFFS_0/a_1310_n400# 0.004131f
C1435 SAR_validpin_0/DFFS_0/a_n50_n400# VDD1v8 0.393439f
C1436 SARclkgen_0/PHIA SAR_validpin_0/DFFRR_1/a_350_n430# 0.065696f
C1437 SAR_validpin_0/DFFR_1/a_n420_n400# SAR_validpin_0/DFFR_1/a_450_n400# 0.252386f
C1438 shift1v8to5_1/A SRLatch5V_0/R 0.003702f
C1439 SAR_validpin_0/DFFR_6/a_n50_n400# ADC_OUT3 0.014524f
C1440 SAR_validpin_0/DFFR_7/a_3210_n400# SAR_validpin_0/DFFRR_0/a_2600_n430# 9.33e-20
C1441 SAR_validpin_0/DFFRR_0/a_350_n430# SAR_validpin_0/DFFRR_1/a_350_n430# 0.014677f
C1442 SAR_validpin_0/DFFR_7/a_n50_n400# SAR_validpin_0/AND2_1/Y 0.002206f
C1443 SARclkgen_0/PHIB SAR_validpin_0/DFFS_0/a_90_n400# 0.638675f
C1444 shift1v8to5_1/A SAR_validpin_0/DFFR_8/a_n420_n400# 0.104957f
C1445 SAR_validpin_0/DFFR_6/a_n420_n400# SAR_validpin_0/OR2_2/A 0.088469f
C1446 SAR_validpin_0/DFFR_3/a_350_n430# SAR_validpin_0/DFFR_3/a_2090_n400# 0.001602f
C1447 SARclkgen_0/PHIB CLK_comp 0.012579f
C1448 SAR_validpin_0/DFFRR_1/a_n560_n400# SAR_validpin_0/DFFRR_1/a_2090_n400# 0.596801f
C1449 SAR_validpin_0/DFFRR_0/D SAR_validpin_0/DFFRR_0/a_450_n400# 0.00584f
C1450 SAR_validpin_0/DFFRR_1/a_1460_n400# SAR_validpin_0/DFFRR_1/a_n560_n400# 0.006485f
C1451 SAR_validpin_0/DFFRR_1/a_1310_n400# SAR_validpin_0/DFFRR_1/a_1130_520# 0.002821f
C1452 VDD1v8 SAR_validpin_0/DFFR_1/a_450_n400# 0.493949f
C1453 SAR_validpin_0/DFFRR_0/D SAR_validpin_0/2_1_MUX_1/a_n1230_n310# 1.109436f
C1454 RST_N SAR_validpin_0/DFFR_0/a_350_n430# 0.232104f
C1455 CDAC_0/b0 CDAC_0/Vout 2.283323f
C1456 SAR_validpin_0/OR2_1/B SAR_validpin_0/DFFRR_0/a_n340_n430# 0.002531f
C1457 SAR_validpin_0/AND2_0/Y SARclkgen_0/PHIA 0.00555f
C1458 SAR_validpin_0/DFFRR_0/a_1310_n400# SAR_validpin_0/DFFRR_0/a_1130_520# 0.002821f
C1459 RST_N SAR_validpin_0/DFFR_4/a_450_n400# 0.295291f
C1460 SAR_validpin_0/DFFRR_0/a_350_n430# SARclkgen_0/PHIA 0.072136f
C1461 SAR_validpin_0/DFFS_0/a_n50_n400# CDAC_0/SPDT_2/out 0.002003f
C1462 SAR_validpin_0/DFFR_3/a_n420_n400# SAR_validpin_0/DFFR_3/a_450_n400# 0.252516f
C1463 SAR_validpin_0/DFFS_0/a_n420_n400# SAR_validpin_0/DFFR_8/a_2600_n430# 0.001817f
C1464 SAR_validpin_0/DFFR_8/a_2600_n430# shift1v8to5_3/A 7.13e-19
C1465 SARclkgen_0/PHIB SAR_validpin_0/DFFR_8/a_2090_n400# 2.44e-19
C1466 shift1v8to5_1/A SAR_validpin_0/DFFR_8/a_90_n400# 0.389043f
C1467 SRLatch5V_0/NQ SRLatch5V_0/Q 2.25731f
C1468 SAR_validpin_0/OR2_0/A SAR_validpin_0/OR2_1/B 0.070527f
C1469 VDD1v8 SAR_validpin_0/DFFR_2/a_2550_720# 0.013971f
C1470 shift1v8to5_4/5v_pfet_1_2_2/D shift1v8to5_1/A 0.001039f
C1471 SAR_validpin_0/DFFR_5/a_n420_n400# SAR_validpin_0/DFFRR_0/a_n560_n400# 1.51e-19
C1472 SAR_validpin_0/DFFR_7/a_350_n430# VDD1v8 1.211349f
C1473 shift1v8to5_1/A CDAC_0/Vcm 0.193276f
C1474 SARclkgen_0/AND2_0/A SARclkgen_0/AND2_1/a_n100_1100# 3.68e-19
C1475 SAR_validpin_0/OR2_0/A SAR_validpin_0/DFFRR_1/a_1130_520# 0.010985f
C1476 SAR_validpin_0/DFFR_6/a_n50_n400# shift1v8to5_1/A 3.81e-19
C1477 RST_N SAR_validpin_0/DFFS_0/a_2550_720# 0.010222f
C1478 CLK5 SARclkgen_0/PHIA 4.66e-19
C1479 SAR_validpin_0/DFFR_8/a_450_n400# SAR_validpin_0/DFFR_8/a_350_n430# 0.980343f
C1480 SAR_validpin_0/DFFRR_1/a_n340_n430# SAR_validpin_0/DFFRR_1/a_n930_n400# 0.049635f
C1481 CDAC_0/Vout SAR_validpin_0/DFFR_0/a_2600_n430# 0.012817f
C1482 CDAC_0/SPDT_0/out CDAC_0/SPDT_1/out 0.110098f
C1483 strongarm_0/5v_pfet_1_1_0/D strongarm_0/5v_nfet_1_1_3/S 0.161178f
C1484 shift1v8to5_1/A SAR_validpin_0/OR2_1/B 0.123331f
C1485 SAR_validpin_0/DFFRR_0/a_1310_n400# SAR_validpin_0/DFFRR_0/a_n560_n400# 0.006054f
C1486 SAR_validpin_0/DFFR_0/a_450_n400# SAR_validpin_0/DFFR_0/a_n50_n400# 0.81908f
C1487 SAR_validpin_0/DFFRR_1/a_n240_n400# SAR_validpin_0/OR2_0/a_n80_n540# 0.001474f
C1488 VALID SARclkgen_0/PHIA 0.018441f
C1489 RST_N SAR_validpin_0/DFFRR_0/a_2600_n430# 0.602036f
C1490 SARclkgen_0/PHIB SAR_validpin_0/DFFRR_0/a_1310_n400# 0.005571f
C1491 SAR_validpin_0/DFFRR_0/a_450_n400# SAR_validpin_0/DFFRR_0/a_1130_520# 0.171763f
C1492 VDD_5V SARclkgen_0/PHIA 0.701029f
C1493 SAR_validpin_0/AND2_0/Y VALID 5.67e-19
C1494 strongarm_0/clk strongarm_0/5v_pfet_1_1_0/D 0.414481f
C1495 shift1v8to5_1/A SAR_validpin_0/DFFRR_1/a_1130_520# 0.003934f
C1496 SAR_validpin_0/AND2_0/Y VDD_5V 0.022764f
C1497 SAR_validpin_0/DFFR_5/a_2600_n430# RST_N 0.624042f
C1498 RST_N shift1v8to5_2/A 4.97e-19
C1499 SAR_validpin_0/DFFR_8/a_3210_n400# SAR_validpin_0/DFFR_8/a_2600_n430# 0.011304f
C1500 SAR_validpin_0/DFFR_6/a_450_n400# SAR_validpin_0/DFFR_6/a_1130_520# 0.171763f
C1501 SARclkgen_0/PHIB SAR_validpin_0/DFFRR_1/a_n340_n430# 0.13658f
C1502 SAR_validpin_0/DFFRR_1/a_2600_n430# SAR_validpin_0/DFFR_4/a_n420_n400# 0.130292f
C1503 SAR_validpin_0/DFFR_7/a_350_n430# SAR_validpin_0/DFFR_7/a_90_n400# 0.349264f
C1504 SAR_validpin_0/DFFR_7/a_1130_520# SAR_validpin_0/DFFR_7/a_1460_n400# 0.002821f
C1505 SAR_validpin_0/DFFR_5/a_n50_n400# SAR_validpin_0/DFFRR_0/a_2090_n400# 4.32e-19
C1506 SAR_validpin_0/DFFR_1/a_350_n430# SARclkgen_0/PHIA 0.122953f
C1507 SAR_validpin_0/DFFRR_1/D SAR_validpin_0/OR2_1/B 0.173758f
C1508 SAR_validpin_0/DFFR_5/a_2090_n400# SAR_validpin_0/DFFR_5/a_n50_n400# 0.596801f
C1509 RST_N SAR_validpin_0/DFFR_4/a_350_n430# 0.211826f
C1510 SARclkgen_0/AND2_0/B CLK 0.146012f
C1511 shift5to1v8_0/5v_pfet_1_2_1/G VDD1v8 1.782683f
C1512 SAR_validpin_0/DFFR_2/a_n50_n400# SAR_validpin_0/DFFR_1/a_n50_n400# 0.001519f
C1513 RST_N SAR_validpin_0/DFFR_6/a_2550_n400# 7.85e-19
C1514 SAR_validpin_0/DFFR_6/a_450_n400# SAR_validpin_0/DFFR_6/a_2090_n400# 0.28571f
C1515 SAR_validpin_0/DFFR_2/a_n50_n400# SAR_validpin_0/DFFR_2/a_2090_n400# 0.596801f
C1516 SARclkgen_0/PHIB SAR_validpin_0/DFFRR_0/a_450_n400# 0.794006f
C1517 SAR_validpin_0/DFFRR_0/a_450_n400# SAR_validpin_0/DFFRR_0/a_n560_n400# 0.805264f
C1518 CLK5 VALID 0.019357f
C1519 SAR_validpin_0/2_1_MUX_1/a_n1230_n310# SAR_validpin_0/DFFRR_0/a_n560_n400# 5.47e-19
C1520 SARclkgen_0/PHIB SAR_validpin_0/2_1_MUX_1/a_n1230_n310# 0.024762f
C1521 SAR_validpin_0/DFFR_3/a_90_n400# SAR_validpin_0/DFFR_3/D 0.272686f
C1522 SAR_validpin_0/OR2_0/A SAR_validpin_0/OR2_0/a_n80_n540# 0.406234f
C1523 CLK5 VDD_5V 8.18083f
C1524 SAR_validpin_0/DFFR_3/a_n420_n400# shift1v8to5_1/A 0.004306f
C1525 SAR_validpin_0/OR2_0/B shift1v8to5_3/A 0.098948f
C1526 SAR_validpin_0/OR2_0/B SAR_validpin_0/OR2_1/a_n80_n540# 0.057567f
C1527 SAR_validpin_0/DFFR_3/a_n50_n400# SAR_validpin_0/DFFR_3/a_2600_n430# 0.101518f
C1528 VDD_5V VALID 0.563559f
C1529 SAR_validpin_0/DFFR_6/a_n50_n400# SAR_validpin_0/DFFR_7/a_3210_n400# 2.41e-19
C1530 SARclkgen_0/PHIA SAR_validpin_0/OR2_2/A 0.18235f
C1531 SAR_validpin_0/DFFR_6/a_450_n400# SAR_validpin_0/DFFR_6/a_1310_n400# 0.014507f
C1532 SRLatch5V_0/S strongarm_0/5v_pfet_1_1_0/D 0.634525f
C1533 SAR_validpin_0/OR2_1/A SAR_validpin_0/OR2_2/a_n80_n540# 0.003716f
C1534 SARclkgen_0/PHIA SAR_validpin_0/2_1_MUX_2/a_n1230_n310# 0.003075f
C1535 SAR_validpin_0/AND2_0/Y SAR_validpin_0/OR2_2/A 0.16457f
C1536 shift1v8to5_1/A SAR_validpin_0/OR2_0/a_n80_n540# 0.032644f
C1537 SAR_validpin_0/DFFRR_1/a_450_n400# shift1v8to5_0/A 0.003108f
C1538 SAR_validpin_0/DFFR_3/a_90_n400# VDD1v8 0.472658f
C1539 SAR_validpin_0/DFFRR_0/a_350_n430# SAR_validpin_0/OR2_2/A 0.005682f
C1540 RST_N SAR_validpin_0/DFFR_8/a_n420_n400# 0.186238f
C1541 shift1v8to5_2/5v_pfet_1_2_0/D CDAC_0/b3 0.35544f
C1542 CLK5 SAR_validpin_0/DFFR_1/a_350_n430# 2.51e-20
C1543 CDAC_0/SPDT_4/out SAR_validpin_0/DFFR_0/a_2090_n400# 0.004957f
C1544 shift1v8to5_1/A SAR_validpin_0/DFFR_7/a_2600_n430# 7.72e-19
C1545 SAR_validpin_0/DFFS_0/a_90_n400# NOT5V_0/Y 5.85e-20
C1546 shift1v8to5_1/A CDAC_0/b0 0.507495f
C1547 shift5to1v8_0/Y SAR_validpin_0/DFFRR_1/a_350_n430# 0.085343f
C1548 VDD_5V SRLatch5V_0/NAND5v_0/5v_nfet_1_2_1/D 0.028206f
C1549 CLK_comp NOT5V_0/Y 0.480907f
C1550 SAR_validpin_0/DFFS_0/a_3210_n400# SAR_validpin_0/DFFS_0/a_450_n400# 0.002723f
C1551 VDD_5V SAR_validpin_0/DFFR_1/a_350_n430# 0.008786f
C1552 SAR_validpin_0/DFFRR_0/a_n420_720# SAR_validpin_0/OR2_1/B 3.52e-21
C1553 SAR_validpin_0/DFFR_2/a_n50_n400# VDD1v8 0.498857f
C1554 SAR_validpin_0/OR2_2/B SAR_validpin_0/OR2_0/B 0.034881f
C1555 SAR_validpin_0/DFFRR_1/a_450_n400# SAR_validpin_0/DFFRR_0/a_1130_520# 3.51e-19
C1556 SAR_validpin_0/DFFR_7/D VDD1v8 0.614759f
C1557 SAR_validpin_0/DFFR_4/a_n50_n400# SAR_validpin_0/DFFR_3/a_450_n400# 6.99e-20
C1558 SAR_validpin_0/DFFR_4/a_450_n400# SAR_validpin_0/DFFR_3/a_n50_n400# 6.99e-20
C1559 SAR_validpin_0/DFFR_2/a_1130_520# SAR_validpin_0/DFFR_2/a_350_n430# 0.24593f
C1560 strongarm_0/5v_pfet_1_1_0/D shift1v8to5_2/A 4.61e-19
C1561 CLK5 SAR_validpin_0/OR2_2/A 1.45e-19
C1562 SARclkgen_0/PHIA shift5to1v8_0/Y 0.407333f
C1563 RST_N SAR_validpin_0/DFFR_8/a_90_n400# 0.05446f
C1564 SAR_validpin_0/DFFR_6/a_3210_n400# SAR_validpin_0/DFFR_6/a_2600_n430# 0.011304f
C1565 VDD1v8 shift1v8to5_4/5v_pfet_1_2_0/D 0.627253f
C1566 SAR_validpin_0/DFFRR_1/D SAR_validpin_0/OR2_0/a_n80_n540# 0.003535f
C1567 VALID SAR_validpin_0/OR2_2/A 0.035633f
C1568 SAR_validpin_0/DFFR_3/D SAR_validpin_0/DFFR_4/a_n420_n400# 0.001673f
C1569 SAR_validpin_0/OR2_1/A SAR_validpin_0/DFFR_7/a_1460_n400# 8.06e-19
C1570 shift1v8to5_3/5v_pfet_1_2_2/D shift1v8to5_0/A 0.068971f
C1571 VALID SAR_validpin_0/2_1_MUX_2/a_n1230_n310# 0.001582f
C1572 shift1v8to5_4/5v_pfet_1_2_2/D RST_N 0.171257f
C1573 VDD_5V SAR_validpin_0/OR2_2/A 0.016029f
C1574 SAR_validpin_0/DFFRR_0/a_350_n430# shift5to1v8_0/Y 0.001715f
C1575 SAR_validpin_0/DFFRR_1/a_450_n400# SAR_validpin_0/DFFRR_1/a_n930_n400# 0.252379f
C1576 SAR_validpin_0/DFFR_0/a_1130_520# SAR_validpin_0/DFFR_0/a_1460_n400# 0.002821f
C1577 RST_N CDAC_0/Vcm 0.002631f
C1578 VDD_5V SAR_validpin_0/2_1_MUX_2/a_n1230_n310# 0.006874f
C1579 shift1v8to5_1/A SAR_validpin_0/DFFR_0/a_2600_n430# 0.074651f
C1580 SAR_validpin_0/OR2_0/a_100_310# shift1v8to5_1/A 0.002583f
C1581 SARclkgen_0/AND2_1/B SARclkgen_0/AND2_0/A 0.076408f
C1582 SAR_validpin_0/DFFR_8/a_450_n400# shift1v8to5_3/A 0.001049f
C1583 SAR_validpin_0/DFFR_6/a_2090_n400# SAR_validpin_0/DFFR_6/a_2600_n430# 0.594476f
C1584 SAR_validpin_0/DFFR_6/a_n50_n400# RST_N 0.178422f
C1585 SAR_validpin_0/DFFR_2/a_350_n430# SAR_validpin_0/DFFR_2/a_1310_n400# 0.006999f
C1586 shift1v8to5_3/5v_pfet_1_2_2/D CDAC_0/b3 0.007495f
C1587 ADC_OUT1 SAR_validpin_0/DFFR_3/a_2600_n430# 0.002535f
C1588 strongarm_0/clk SARclkgen_0/AND2_0/a_n100_1100# 0.015733f
C1589 SAR_validpin_0/OR2_1/A SAR_validpin_0/DFFR_5/a_n50_n400# 0.152992f
C1590 VDD1v8 SAR_validpin_0/DFFR_4/a_n420_n400# 0.548475f
C1591 SAR_validpin_0/DFFR_4/a_2090_n400# SAR_validpin_0/DFFR_4/a_n50_n400# 0.596801f
C1592 SAR_validpin_0/DFFR_1/a_1310_n400# SARclkgen_0/PHIA 0.007912f
C1593 RST_N SAR_validpin_0/OR2_1/B 0.353507f
C1594 CDAC_0/SPDT_0/out VDD1v8 7.64e-20
C1595 shift1v8to5_0/5v_pfet_1_2_2/D shift1v8to5_3/A 6.82e-19
C1596 RST_N SAR_validpin_0/DFFRR_0/a_2550_720# 0.011485f
C1597 SAR_validpin_0/DFFS_0/a_2090_n400# SAR_validpin_0/DFFR_8/a_350_n430# 0.001457f
C1598 SAR_validpin_0/DFFR_7/D SAR_validpin_0/DFFR_7/a_90_n400# 0.270221f
C1599 SARclkgen_0/PHIB SAR_validpin_0/DFFRR_1/a_450_n400# 0.800272f
C1600 shift1v8to5_0/A SAR_validpin_0/DFFR_1/a_90_n400# 9.52e-21
C1601 RST_N SAR_validpin_0/DFFRR_1/a_1130_520# 0.430309f
C1602 SAR_validpin_0/DFFR_8/a_2600_n430# shift1v8to5_2/A 5.75e-19
C1603 SAR_validpin_0/DFFR_7/a_2600_n430# SAR_validpin_0/DFFR_7/a_3210_n400# 0.011304f
C1604 shift1v8to5_0/5v_pfet_1_2_0/D shift1v8to5_0/5v_pfet_1_2_2/D 0.023009f
C1605 CLK5 shift5to1v8_0/Y 0.002515f
C1606 SARclkgen_0/PHIA SARclkgen_0/AND2_1/a_n100_1100# 0.440341f
C1607 strongarm_0/5v_pfet_1_1_0/D SRLatch5V_0/R 0.443217f
C1608 SAR_validpin_0/DFFR_0/a_n50_n400# SARclkgen_0/PHIA 1.990092f
C1609 SAR_validpin_0/DFFR_0/a_450_n400# SAR_validpin_0/DFFR_0/a_n420_n400# 0.252386f
C1610 VALID shift5to1v8_0/Y 1.289242f
C1611 VDD_5V shift5to1v8_0/Y 0.266377f
C1612 CDAC_0/SPDT_4/out SAR_validpin_0/DFFR_1/a_450_n400# 0.005567f
C1613 SAR_validpin_0/DFFR_4/a_n50_n400# SAR_validpin_0/OR2_0/A 0.154485f
C1614 SAR_validpin_0/DFFR_3/a_90_n400# SAR_validpin_0/AND2_1/Y 0.590322f
C1615 SAR_validpin_0/AND2_0/Y ADC_OUT0 0.006471f
C1616 SAR_validpin_0/OR2_2/A SAR_validpin_0/2_1_MUX_2/a_n1230_n310# 0.230206f
C1617 SAR_validpin_0/DFFS_0/a_90_n400# CDAC_0/Vout 0.003508f
C1618 SRLatch5V_0/NQ CLK_comp 0.004024f
C1619 SAR_validpin_0/DFFR_8/a_1130_520# SAR_validpin_0/DFFS_0/a_600_n400# 7.24e-20
C1620 SAR_validpin_0/DFFR_3/D SAR_validpin_0/DFFRR_1/a_2550_n400# 6.11e-19
C1621 SAR_validpin_0/DFFR_3/a_1460_n400# SAR_validpin_0/DFFR_3/D 2.74e-19
C1622 SAR_validpin_0/DFFR_3/a_n50_n400# SAR_validpin_0/DFFR_4/a_350_n430# 8.42e-20
C1623 SARclkgen_0/PHIA CDAC_0/b1 0.002716f
C1624 CLK_comp CDAC_0/Vout 0.327564f
C1625 SAR_validpin_0/DFFR_7/a_n420_n400# SAR_validpin_0/DFFRR_0/a_450_n400# 2.19e-20
C1626 SARclkgen_0/PHIB shift1v8to5_3/5v_pfet_1_2_2/D 0.00669f
C1627 SRLatch5V_0/S SARclkgen_0/AND2_0/a_n100_1100# 0.004331f
C1628 SAR_validpin_0/AND2_0/Y SAR_validpin_0/DFFR_3/a_3210_n400# 4.1e-19
C1629 SAR_validpin_0/DFFR_1/a_1310_n400# VDD_5V 9.85e-19
C1630 shift1v8to5_1/A SAR_validpin_0/DFFR_4/a_n50_n400# 2.81e-20
C1631 SAR_validpin_0/DFFR_1/a_350_n430# shift5to1v8_0/Y 2.09e-19
C1632 SAR_validpin_0/DFFR_4/a_n420_n400# SAR_validpin_0/DFFR_3/a_1130_520# 3.28e-20
C1633 SAR_validpin_0/DFFR_8/a_450_n400# SAR_validpin_0/DFFR_8/a_1310_n400# 0.014507f
C1634 SARclkgen_0/PHIA SAR_validpin_0/DFFR_2/a_90_n400# 0.077818f
C1635 SAR_validpin_0/DFFR_3/a_n420_n400# RST_N 0.222772f
C1636 shift1v8to5_2/5v_pfet_1_2_2/D SRLatch5V_0/NAND5v_1/5v_nfet_1_2_1/D 1.86e-19
C1637 shift5to1v8_0/5v_pfet_1_2_1/G CDAC_0/b2 0.004615f
C1638 SAR_validpin_0/DFFRR_0/a_2550_n400# SAR_validpin_0/DFFRR_0/a_2090_n400# 0.006257f
C1639 SAR_validpin_0/DFFR_3/a_1460_n400# VDD1v8 9.65e-19
C1640 SAR_validpin_0/DFFR_7/a_450_n400# SAR_validpin_0/OR2_2/B 0.003285f
C1641 CLK5 SARclkgen_0/AND2_1/a_n100_1100# 4.68e-19
C1642 shift1v8to5_1/A SAR_validpin_0/DFFR_3/a_2550_720# 5.86e-19
C1643 SAR_validpin_0/DFFRR_1/a_2550_n400# VDD1v8 4.37e-19
C1644 SAR_validpin_0/DFFS_0/a_350_n430# SAR_validpin_0/DFFS_0/a_450_n400# 0.438905f
C1645 SAR_validpin_0/DFFR_8/a_2600_n430# SAR_validpin_0/DFFR_8/a_n420_n400# 4.26e-20
C1646 SAR_validpin_0/DFFR_6/a_350_n430# SAR_validpin_0/DFFR_5/a_n50_n400# 8.42e-20
C1647 SAR_validpin_0/DFFR_2/a_350_n430# SARclkgen_0/PHIA 0.071069f
C1648 SAR_validpin_0/DFFR_0/a_n50_n400# VDD_5V 0.009555f
C1649 CDAC_0/Vcm strongarm_0/5v_pfet_1_1_0/D 0.330221f
C1650 VDD_5V SARclkgen_0/AND2_1/a_n100_1100# 0.005072f
C1651 SAR_validpin_0/DFFR_0/a_2090_n400# SAR_validpin_0/OR2_2/a_n80_n540# 0.003652f
C1652 SAR_validpin_0/DFFR_8/a_1130_520# shift1v8to5_0/A 9.13e-19
C1653 RST_N SAR_validpin_0/DFFR_7/a_2600_n430# 0.54174f
C1654 SARclkgen_0/PHIB SAR_validpin_0/DFFR_1/a_90_n400# 0.633367f
C1655 strongarm_0/5v_pfet_1_1_3/D SRLatch5V_0/NQ 8.45e-20
C1656 SARclkgen_0/AND2_1/a_90_n200# SARclkgen_0/AND2_0/A 3.43e-19
C1657 SAR_validpin_0/OR2_1/A SAR_validpin_0/OR2_1/a_100_310# 2.93e-19
C1658 shift5to1v8_0/Y SAR_validpin_0/OR2_2/A 0.485377f
C1659 SAR_validpin_0/DFFR_5/a_3210_n400# ADC_OUT2 0.00729f
C1660 SAR_validpin_0/DFFR_1/a_1310_n400# SAR_validpin_0/DFFR_1/a_350_n430# 0.006999f
C1661 strongarm_0/5v_pfet_1_1_3/D CDAC_0/Vout 0.325871f
C1662 shift5to1v8_0/Y SAR_validpin_0/2_1_MUX_2/a_n1230_n310# 0.412886f
C1663 VDD_5V ADC_OUT0 0.248235f
C1664 CLK5 CDAC_0/b1 3.456772f
C1665 shift1v8to5_2/A SAR_validpin_0/OR2_0/B 0.009639f
C1666 SAR_validpin_0/DFFR_0/a_450_n400# SAR_validpin_0/DFFR_0/a_1310_n400# 0.014507f
C1667 CLK5 SAR_validpin_0/DFFR_2/a_90_n400# 4.07e-21
C1668 VDD_5V SAR_validpin_0/DFFR_3/a_3210_n400# 0.001782f
C1669 SAR_validpin_0/DFFR_4/a_n420_n400# SAR_validpin_0/AND2_1/Y 0.772994f
C1670 SAR_validpin_0/DFFS_0/a_n50_n400# SAR_validpin_0/DFFS_0/a_350_n430# 0.619493f
C1671 VDD_5V CDAC_0/b1 2.595888f
C1672 VDD1v8 SARclkgen_0/AND2_0/A 0.510329f
C1673 SAR_validpin_0/DFFR_7/a_n50_n400# SAR_validpin_0/DFFR_7/a_1460_n400# 0.006584f
C1674 SAR_validpin_0/DFFR_6/a_450_n400# SAR_validpin_0/DFFR_6/a_1460_n400# 0.010382f
C1675 SAR_validpin_0/DFFS_0/a_2090_n400# CDAC_0/SPDT_3/out 0.004555f
C1676 VDD_5V SAR_validpin_0/DFFR_2/a_90_n400# 0.006065f
C1677 RST_N SAR_validpin_0/DFFR_0/a_2600_n430# 0.641247f
C1678 CDAC_0/Vcm SAR_validpin_0/DFFR_1/a_3210_n400# 2.69e-19
C1679 SAR_validpin_0/DFFR_3/a_1460_n400# SAR_validpin_0/DFFR_3/a_1130_520# 0.002821f
C1680 SAR_validpin_0/DFFR_2/a_1460_n400# SAR_validpin_0/DFFR_2/a_450_n400# 0.010382f
C1681 SAR_validpin_0/DFFR_1/a_450_n400# SAR_validpin_0/DFFR_1/a_1130_520# 0.171763f
C1682 SAR_validpin_0/DFFR_0/a_450_n400# VDD1v8 0.483884f
C1683 VDD_5V SAR_validpin_0/DFFR_2/a_350_n430# 0.006838f
C1684 SAR_validpin_0/DFFR_0/a_n50_n400# SAR_validpin_0/OR2_2/A 0.003272f
C1685 SAR_validpin_0/DFFR_4/a_3210_n400# SAR_validpin_0/DFFR_3/a_2600_n430# 9.33e-20
C1686 SAR_validpin_0/DFFR_2/a_1130_520# SAR_validpin_0/DFFR_2/a_2090_n400# 1.24e-20
C1687 shift1v8to5_2/5v_pfet_1_2_0/D shift1v8to5_1/5v_pfet_1_2_2/D 0.007373f
C1688 SAR_validpin_0/DFFS_0/a_n420_n400# SAR_validpin_0/DFFS_0/a_2090_n400# 0.322053f
C1689 SAR_validpin_0/DFFR_3/a_2090_n400# SAR_validpin_0/DFFR_3/a_2600_n430# 0.594476f
C1690 SAR_validpin_0/DFFRR_1/a_350_n430# SAR_validpin_0/DFFRR_1/a_n420_720# 0.316859f
C1691 SARclkgen_0/AND2_0/a_n100_1100# SRLatch5V_0/R 1.66e-19
C1692 SAR_validpin_0/DFFR_8/a_450_n400# SAR_validpin_0/DFFS_0/a_2550_720# 2.39e-19
C1693 SAR_validpin_0/DFFR_5/a_2600_n430# SAR_validpin_0/DFFR_6/a_3210_n400# 9.33e-20
C1694 SAR_validpin_0/AND2_0/Y SAR_validpin_0/DFFR_4/a_2550_n400# 0.001071f
C1695 SAR_validpin_0/2_1_MUX_0/a_n1230_n310# SAR_validpin_0/DFFRR_1/a_n340_n430# 5.21e-19
C1696 SAR_validpin_0/DFFRR_1/a_2600_n430# SAR_validpin_0/DFFRR_1/a_350_n430# 2.63e-19
C1697 SAR_validpin_0/DFFR_0/a_1130_520# SAR_validpin_0/DFFR_0/a_2090_n400# 1.24e-20
C1698 shift1v8to5_5/5v_pfet_1_2_2/D NOT5V_0/Y 0.063931f
C1699 SAR_validpin_0/AND2_2/a_n100_1100# SARclkgen_0/PHIA 0.001308f
C1700 SAR_validpin_0/DFFR_8/a_n50_n400# shift1v8to5_1/A 0.147795f
C1701 SAR_validpin_0/DFFR_8/a_1130_520# SARclkgen_0/PHIB 0.115693f
C1702 SARclkgen_0/PHIB SAR_validpin_0/DFFR_2/a_n420_n400# 0.659962f
C1703 CDAC_0/SPDT_0/out CDAC_0/b2 1.989972f
C1704 SAR_validpin_0/DFFS_0/a_1130_520# VDD1v8 0.564395f
C1705 SARclkgen_0/PHIB SAR_validpin_0/DFFR_0/a_3210_n400# 0.001667f
C1706 SAR_validpin_0/DFFS_0/a_1130_520# SAR_validpin_0/DFFS_0/a_1310_n400# 0.002821f
C1707 strongarm_0/clk SARclkgen_0/AND2_0/a_90_n200# 7.28e-20
C1708 SAR_validpin_0/DFFR_5/a_2600_n430# SAR_validpin_0/DFFR_6/a_2090_n400# 3.11e-20
C1709 SAR_validpin_0/DFFR_5/a_2090_n400# SAR_validpin_0/DFFR_6/a_2600_n430# 3.11e-20
C1710 SAR_validpin_0/DFFR_6/a_n420_n400# VDD1v8 0.539823f
C1711 SARclkgen_0/PHIA SAR_validpin_0/DFFRR_1/a_n420_720# 0.075824f
C1712 SARclkgen_0/AND2_1/B SARclkgen_0/PHIA 0.486153f
C1713 SAR_validpin_0/OR2_1/A SAR_validpin_0/DFFRR_0/a_2550_n400# 0.001629f
C1714 SAR_validpin_0/DFFR_8/a_450_n400# shift1v8to5_2/A 8.45e-19
C1715 SAR_validpin_0/DFFRR_0/a_n930_n400# SAR_validpin_0/DFFRR_1/a_350_n430# 1.21e-19
C1716 SARclkgen_0/PHIB SAR_validpin_0/DFFS_0/a_600_n400# 0.407265f
C1717 shift1v8to5_1/A SAR_validpin_0/DFFS_0/a_90_n400# 0.358061f
C1718 SAR_validpin_0/DFFR_3/a_1460_n400# SAR_validpin_0/AND2_1/Y 0.009764f
C1719 SAR_validpin_0/DFFRR_1/a_2600_n430# SARclkgen_0/PHIA 0.135634f
C1720 SAR_validpin_0/DFFRR_0/D SAR_validpin_0/DFFRR_0/a_n560_n400# 0.094686f
C1721 shift1v8to5_1/A CLK_comp 0.475927f
C1722 SAR_validpin_0/DFFRR_0/a_350_n430# SAR_validpin_0/DFFRR_1/a_n420_720# 6.99e-20
C1723 SAR_validpin_0/AND2_0/Y SAR_validpin_0/DFFRR_1/a_2600_n430# 0.003005f
C1724 SARclkgen_0/PHIB SAR_validpin_0/DFFRR_0/D 0.326768f
C1725 strongarm_0/clk SARclkgen_0/AND2_0/B 0.010539f
C1726 SAR_validpin_0/DFFR_2/a_1130_520# VDD1v8 0.556693f
C1727 SAR_validpin_0/DFFRR_1/a_n340_n430# SAR_validpin_0/DFFRR_1/a_n240_n400# 0.004376f
C1728 SAR_validpin_0/2_1_MUX_0/a_n1230_n310# SAR_validpin_0/2_1_MUX_1/a_n1230_n310# 0.00449f
C1729 SARclkgen_0/PHIA SAR_validpin_0/DFFR_0/a_n420_n400# 0.130684f
C1730 SAR_validpin_0/DFFS_0/a_2090_n400# SAR_validpin_0/OR2_2/B 0.53312f
C1731 CLK5 CDAC_0/SPDT_1/out 1.307544f
C1732 VDD_5V SAR_validpin_0/DFFR_4/a_2550_n400# 5.26e-19
C1733 SAR_validpin_0/DFFR_6/a_2550_n400# SAR_validpin_0/DFFR_6/a_2090_n400# 0.006257f
C1734 RST_N SAR_validpin_0/DFFR_4/a_n50_n400# 0.174579f
C1735 SAR_validpin_0/DFFRR_0/a_n930_n400# SARclkgen_0/PHIA 0.138571f
C1736 SAR_validpin_0/DFFR_4/a_n420_n400# SAR_validpin_0/DFFRR_1/a_2090_n400# 0.010629f
C1737 SAR_validpin_0/DFFR_3/a_n420_n400# SAR_validpin_0/DFFR_3/a_n50_n400# 0.115539f
C1738 CDAC_0/Vcm SAR_validpin_0/OR2_0/B 0.003154f
C1739 VDD_5V CDAC_0/SPDT_1/out 1.694376f
C1740 VDD1v8 SAR_validpin_0/DFFR_2/a_1310_n400# 0.001032f
C1741 shift1v8to5_1/A SAR_validpin_0/DFFR_8/a_2090_n400# 0.001304f
C1742 SAR_validpin_0/DFFRR_1/a_n340_n430# SAR_validpin_0/DFFRR_0/a_n340_n430# 0.003308f
C1743 SAR_validpin_0/DFFR_8/a_1460_n400# SAR_validpin_0/DFFR_8/a_350_n430# 0.015634f
C1744 RST_N SAR_validpin_0/DFFR_3/a_2550_720# 0.011485f
C1745 SAR_validpin_0/DFFRR_0/a_350_n430# SAR_validpin_0/DFFRR_0/a_n930_n400# 0.316122f
C1746 SARclkgen_0/AND2_1/B CLK5 1.82e-19
C1747 SARclkgen_0/PHIB shift1v8to5_0/A 0.437344f
C1748 SAR_validpin_0/DFFRR_1/a_n930_n400# SAR_validpin_0/DFFRR_0/a_1130_520# 3.28e-20
C1749 SAR_validpin_0/DFFR_4/a_2600_n430# SAR_validpin_0/DFFR_4/a_n420_n400# 4.26e-20
C1750 SAR_validpin_0/OR2_1/B SAR_validpin_0/OR2_0/B 0.17177f
C1751 shift1v8to5_2/5v_pfet_1_2_2/D strongarm_0/5v_nfet_1_1_3/S 6.97e-19
C1752 SARclkgen_0/AND2_1/B VDD_5V 0.005968f
C1753 NOT5V_0/Y SAR_validpin_0/DFFR_1/a_90_n400# 5.85e-20
C1754 SAR_validpin_0/OR2_0/A SAR_validpin_0/DFFRR_1/a_n340_n430# 0.118263f
C1755 SAR_validpin_0/DFFR_6/a_n420_n400# SAR_validpin_0/DFFR_5/a_450_n400# 2.19e-20
C1756 SAR_validpin_0/DFFR_8/a_450_n400# SAR_validpin_0/DFFR_8/a_n420_n400# 0.252464f
C1757 shift1v8to5_2/5v_pfet_1_2_2/D strongarm_0/clk 8.91e-19
C1758 shift1v8to5_1/A SAR_validpin_0/DFFRR_0/a_1310_n400# 4.36e-19
C1759 SAR_validpin_0/DFFR_5/a_90_n400# VDD1v8 0.46792f
C1760 SAR_validpin_0/DFFRR_0/a_450_n400# SAR_validpin_0/DFFRR_0/a_n340_n430# 0.059006f
C1761 SAR_validpin_0/DFFRR_0/a_n560_n400# SAR_validpin_0/DFFRR_0/a_1130_520# 0.003341f
C1762 SRLatch5V_0/S SARclkgen_0/AND2_0/B 5e-19
C1763 SARclkgen_0/PHIB SAR_validpin_0/DFFRR_0/a_1130_520# 0.115688f
C1764 VDD_5V SAR_validpin_0/DFFR_0/a_n420_n400# 0.002664f
C1765 SAR_validpin_0/DFFR_2/a_1130_520# SAR_validpin_0/DFFR_3/a_1130_520# 0.009107f
C1766 SAR_validpin_0/AND2_2/a_n100_1100# SAR_validpin_0/DFFR_1/a_350_n430# 3.42e-19
C1767 SAR_validpin_0/2_1_MUX_1/a_n1230_n310# SAR_validpin_0/DFFRR_0/a_n340_n430# 5.77e-19
C1768 SARclkgen_0/PHIA SAR_validpin_0/DFFR_2/a_2090_n400# 0.465379f
C1769 SARclkgen_0/PHIA SAR_validpin_0/DFFR_1/a_n50_n400# 2.006026f
C1770 SAR_validpin_0/DFFR_3/D SAR_validpin_0/DFFRR_1/a_350_n430# 0.001019f
C1771 SAR_validpin_0/DFFR_6/a_n50_n400# SAR_validpin_0/DFFR_6/a_1130_520# 0.003341f
C1772 SAR_validpin_0/DFFR_6/a_450_n400# SAR_validpin_0/DFFR_6/a_350_n430# 0.980343f
C1773 SAR_validpin_0/OR2_0/A SAR_validpin_0/DFFR_4/a_90_n400# 0.272161f
C1774 SAR_validpin_0/DFFR_0/a_350_n430# SAR_validpin_0/DFFS_0/a_2090_n400# 3.16e-20
C1775 shift1v8to5_1/A SAR_validpin_0/DFFRR_1/a_n340_n430# 0.324474f
C1776 SAR_validpin_0/DFFR_6/a_n50_n400# SAR_validpin_0/DFFR_6/a_3210_n400# 2.5e-19
C1777 SARclkgen_0/PHIB SAR_validpin_0/DFFRR_1/a_n930_n400# 0.819313f
C1778 SARclkgen_0/PHIA SARclkgen_0/AND2_1/a_90_n200# 0.001357f
C1779 SAR_validpin_0/DFFR_8/a_450_n400# SAR_validpin_0/DFFR_8/a_90_n400# 0.143111f
C1780 SAR_validpin_0/DFFR_7/a_350_n430# SAR_validpin_0/DFFR_7/a_1460_n400# 0.015634f
C1781 SAR_validpin_0/DFFR_0/a_1310_n400# SARclkgen_0/PHIA 0.007627f
C1782 SAR_validpin_0/OR2_1/A SAR_validpin_0/OR2_1/a_n80_n540# 0.477685f
C1783 SAR_validpin_0/OR2_1/A shift1v8to5_3/A 0.070498f
C1784 VDD1v8 SAR_validpin_0/DFFRR_1/a_350_n430# 1.230003f
C1785 SAR_validpin_0/DFFR_3/D SARclkgen_0/PHIA 0.103446f
C1786 SAR_validpin_0/DFFR_6/a_n420_n400# SAR_validpin_0/AND2_1/Y 0.67101f
C1787 SAR_validpin_0/DFFR_1/a_n420_n400# SARclkgen_0/PHIA 0.160937f
C1788 SAR_validpin_0/AND2_0/Y SAR_validpin_0/DFFR_3/D 0.156627f
C1789 SAR_validpin_0/DFFR_3/a_3210_n400# ADC_OUT0 0.007057f
C1790 SAR_validpin_0/DFFRR_1/a_2550_n400# SAR_validpin_0/DFFRR_1/a_2090_n400# 0.006257f
C1791 SAR_validpin_0/DFFR_3/a_n420_n400# SAR_validpin_0/OR2_0/B 0.059446f
C1792 SAR_validpin_0/DFFR_2/a_n420_n400# SAR_validpin_0/DFFR_1/a_2600_n430# 0.130291f
C1793 SAR_validpin_0/2_1_MUX_0/a_n1230_n310# SAR_validpin_0/DFFRR_1/a_450_n400# 1.95e-21
C1794 SAR_validpin_0/DFFR_6/a_n50_n400# SAR_validpin_0/DFFR_6/a_2090_n400# 0.596801f
C1795 shift1v8to5_1/A SAR_validpin_0/DFFRR_0/a_450_n400# 0.073428f
C1796 SARclkgen_0/PHIB SAR_validpin_0/DFFRR_0/a_n560_n400# 0.340907f
C1797 shift1v8to5_1/A SAR_validpin_0/2_1_MUX_1/a_n1230_n310# 1.39e-19
C1798 CLK5 SAR_validpin_0/DFFR_1/a_n50_n400# 2.12e-19
C1799 SRLatch5V_0/S shift1v8to5_2/5v_pfet_1_2_2/D 5.19e-19
C1800 SAR_validpin_0/DFFS_0/a_450_n400# SAR_validpin_0/DFFR_8/a_2550_720# 2.39e-19
C1801 SAR_validpin_0/DFFR_6/a_450_n400# SAR_validpin_0/DFFR_7/a_2090_n400# 2.95e-20
C1802 SARclkgen_0/PHIA VDD1v8 8.799557f
C1803 SAR_validpin_0/OR2_0/B SAR_validpin_0/OR2_0/a_n80_n540# 0.255838f
C1804 SRLatch5V_0/NQ shift1v8to5_3/5v_pfet_1_2_2/D 7.32e-19
C1805 SAR_validpin_0/OR2_2/B SAR_validpin_0/DFFR_0/a_1460_n400# 1.55e-19
C1806 SARclkgen_0/PHIA SAR_validpin_0/DFFS_0/a_1310_n400# 0.008701f
C1807 SAR_validpin_0/DFFR_8/a_n50_n400# RST_N 0.177322f
C1808 SAR_validpin_0/DFFR_6/a_n50_n400# SAR_validpin_0/DFFR_6/a_1310_n400# 0.006175f
C1809 SAR_validpin_0/DFFRR_1/D SAR_validpin_0/DFFRR_1/a_n340_n430# 0.347673f
C1810 SAR_validpin_0/DFFRR_1/a_n560_n400# shift1v8to5_3/A 0.002519f
C1811 SAR_validpin_0/OR2_1/a_n80_n540# SAR_validpin_0/DFFRR_1/a_n560_n400# 0.002408f
C1812 SAR_validpin_0/DFFS_0/a_2090_n400# SAR_validpin_0/DFFS_0/a_2550_720# 0.001629f
C1813 SAR_validpin_0/AND2_0/Y SAR_validpin_0/AND2_0/a_90_n200# 5.61e-19
C1814 SAR_validpin_0/AND2_0/Y VDD1v8 3.918084f
C1815 VDD_5V SAR_validpin_0/DFFR_1/a_n50_n400# 0.002583f
C1816 VDD_5V SAR_validpin_0/DFFR_2/a_2090_n400# 0.024661f
C1817 SAR_validpin_0/DFFR_5/a_90_n400# SAR_validpin_0/DFFR_5/a_450_n400# 0.143349f
C1818 SAR_validpin_0/DFFR_0/a_3210_n400# NOT5V_0/Y 4.44e-20
C1819 SAR_validpin_0/OR2_1/A SAR_validpin_0/OR2_2/B 0.233643f
C1820 RST_N SAR_validpin_0/DFFR_5/a_1130_520# 0.430407f
C1821 SAR_validpin_0/DFFRR_0/a_350_n430# VDD1v8 1.22947f
C1822 SARclkgen_0/PHIA SAR_validpin_0/DFFRR_0/a_3210_n400# 4.1e-19
C1823 SAR_validpin_0/DFFRR_0/a_n930_n400# SAR_validpin_0/OR2_2/A 0.003733f
C1824 SAR_validpin_0/AND2_0/Y SAR_validpin_0/DFFRR_0/a_3210_n400# 0.001496f
C1825 RST_N SAR_validpin_0/DFFS_0/a_90_n400# 0.086757f
C1826 SAR_validpin_0/AND2_2/a_n100_1100# shift5to1v8_0/Y 0.160138f
C1827 SAR_validpin_0/DFFRR_1/a_450_n400# SAR_validpin_0/DFFRR_1/a_n240_n400# 2.93e-19
C1828 SAR_validpin_0/DFFRR_0/a_2090_n400# SAR_validpin_0/DFFRR_0/a_2600_n430# 0.594476f
C1829 SAR_validpin_0/DFFS_0/a_600_n400# NOT5V_0/Y 2.33e-19
C1830 CLK5 SAR_validpin_0/DFFR_1/a_n420_n400# 1.05e-19
C1831 RST_N CLK_comp 0.960691f
C1832 SAR_validpin_0/DFFRR_0/a_n930_n400# SAR_validpin_0/2_1_MUX_2/a_n1230_n310# 0.00477f
C1833 SAR_validpin_0/DFFRR_1/a_450_n400# SAR_validpin_0/DFFRR_1/a_1310_n400# 0.014507f
C1834 SAR_validpin_0/DFFRR_1/a_3210_n400# SAR_validpin_0/OR2_0/A 0.006839f
C1835 SARclkgen_0/PHIA SAR_validpin_0/DFFR_1/a_2550_720# 0.003196f
C1836 SAR_validpin_0/DFFRR_0/D SAR_validpin_0/DFFR_7/a_n420_n400# 8.62e-21
C1837 SAR_validpin_0/DFFR_2/a_n420_n400# SAR_validpin_0/DFFR_1/a_2090_n400# 0.010629f
C1838 shift5to1v8_0/Y SAR_validpin_0/DFFRR_1/a_n420_720# 0.183646f
C1839 SAR_validpin_0/DFFR_2/a_350_n430# SAR_validpin_0/DFFR_2/a_90_n400# 0.349264f
C1840 CDAC_0/Vout SAR_validpin_0/DFFR_1/a_90_n400# 0.003839f
C1841 VDD_5V SAR_validpin_0/DFFR_1/a_n420_n400# 0.007232f
C1842 SAR_validpin_0/DFFR_1/a_350_n430# SAR_validpin_0/DFFR_1/a_n50_n400# 0.260805f
C1843 SARclkgen_0/PHIA CDAC_0/SPDT_2/out 0.004664f
C1844 SARclkgen_0/AND2_0/B SRLatch5V_0/R 0.002583f
C1845 SARclkgen_0/PHIA SAR_validpin_0/DFFR_7/a_90_n400# 0.069925f
C1846 shift1v8to5_2/5v_pfet_1_2_2/D shift1v8to5_2/A 1.037705f
C1847 CLK5 VDD1v8 0.570617f
C1848 SAR_validpin_0/DFFR_6/a_350_n430# SAR_validpin_0/DFFR_6/a_2600_n430# 2.63e-19
C1849 SAR_validpin_0/OR2_0/a_100_310# SAR_validpin_0/OR2_0/B 0.010159f
C1850 SAR_validpin_0/DFFR_4/a_n50_n400# SAR_validpin_0/DFFR_3/a_n50_n400# 0.015291f
C1851 SAR_validpin_0/DFFR_5/a_2090_n400# SAR_validpin_0/DFFR_5/a_2600_n430# 0.594476f
C1852 SAR_validpin_0/DFFR_5/a_90_n400# SAR_validpin_0/AND2_1/Y 0.580018f
C1853 SAR_validpin_0/AND2_0/Y SAR_validpin_0/DFFR_5/a_1460_n400# 0.004103f
C1854 SAR_validpin_0/DFFRR_0/a_n420_720# SAR_validpin_0/DFFRR_1/a_n340_n430# 3.16e-19
C1855 RST_N SAR_validpin_0/DFFR_8/a_2090_n400# 0.543991f
C1856 VALID VDD1v8 1.708058f
C1857 SAR_validpin_0/DFFS_0/a_n50_n400# SAR_validpin_0/DFFR_8/a_350_n430# 7.45e-20
C1858 VDD_5V VDD1v8 13.255733f
C1859 SAR_validpin_0/DFFR_3/a_450_n400# SAR_validpin_0/DFFR_3/a_1310_n400# 0.014507f
C1860 NOT5V_0/Y shift1v8to5_0/A 0.0041f
C1861 SAR_validpin_0/DFFR_3/D SAR_validpin_0/DFFR_1/a_350_n430# 3.71e-20
C1862 SAR_validpin_0/OR2_0/A SAR_validpin_0/DFFRR_1/a_450_n400# 0.149954f
C1863 SAR_validpin_0/DFFRR_0/a_n930_n400# shift5to1v8_0/Y 0.439765f
C1864 SAR_validpin_0/DFFR_5/a_n420_n400# RST_N 0.284052f
C1865 SAR_validpin_0/AND2_0/Y SAR_validpin_0/DFFR_3/a_1130_520# 2.72e-19
C1866 SAR_validpin_0/DFFR_1/a_350_n430# SAR_validpin_0/DFFR_1/a_n420_n400# 0.316282f
C1867 SAR_validpin_0/DFFR_0/a_350_n430# SAR_validpin_0/DFFR_0/a_1460_n400# 0.015634f
C1868 SAR_validpin_0/DFFR_0/a_450_n400# CDAC_0/SPDT_4/out 0.003342f
C1869 SAR_validpin_0/AND2_0/Y SAR_validpin_0/DFFR_5/a_450_n400# 0.352442f
C1870 shift1v8to5_1/5v_pfet_1_2_2/D CDAC_0/b3 0.050368f
C1871 SAR_validpin_0/DFFR_3/a_90_n400# SAR_validpin_0/DFFR_3/a_350_n430# 0.349264f
C1872 VDD1v8 SRLatch5V_0/NAND5v_0/5v_nfet_1_2_1/D 0.028132f
C1873 NOT5V_0/Y CDAC_0/b3 2.819364f
C1874 SAR_validpin_0/DFFR_0/a_2550_720# VDD1v8 0.013971f
C1875 shift1v8to5_2/5v_pfet_1_2_0/D shift1v8to5_1/A 9.75e-19
C1876 CLK5 CDAC_0/SPDT_2/out 1.354471f
C1877 SAR_validpin_0/DFFR_1/a_1460_n400# SARclkgen_0/PHIB 0.011691f
C1878 SAR_validpin_0/DFFR_1/a_350_n430# VDD1v8 1.23288f
C1879 SAR_validpin_0/DFFRR_0/a_n420_720# SAR_validpin_0/DFFRR_0/a_450_n400# 0.097799f
C1880 shift1v8to5_2/5v_pfet_1_2_2/D SRLatch5V_0/R 5.87e-19
C1881 shift1v8to5_1/A shift1v8to5_5/5v_pfet_1_2_2/D 9.94e-19
C1882 SARclkgen_0/AND2_1/B SARclkgen_0/AND2_1/a_n100_1100# 0.163783f
C1883 SAR_validpin_0/DFFS_0/a_2090_n400# SAR_validpin_0/DFFR_8/a_n420_n400# 0.001821f
C1884 SAR_validpin_0/DFFRR_0/a_n420_720# SAR_validpin_0/2_1_MUX_1/a_n1230_n310# 0.001979f
C1885 SAR_validpin_0/DFFR_7/a_n420_n400# SAR_validpin_0/DFFRR_0/a_1130_520# 3.28e-20
C1886 shift1v8to5_1/A SAR_validpin_0/DFFRR_1/a_450_n400# 0.101892f
C1887 SAR_validpin_0/DFFR_4/a_2550_720# VDD_5V 8.67e-19
C1888 VALID SAR_validpin_0/DFFR_7/a_90_n400# 3.37e-19
C1889 SAR_validpin_0/AND2_0/a_n100_1100# SARclkgen_0/PHIB 0.003621f
C1890 CDAC_0/b0 shift1v8to5_0/5v_pfet_1_2_2/D 0.001507f
C1891 VDD_5V SAR_validpin_0/DFFR_7/a_90_n400# 0.007719f
C1892 CDAC_0/SPDT_1/out CDAC_0/b1 1.360744f
C1893 RST_N SAR_validpin_0/DFFRR_1/a_n340_n430# 9.12e-19
C1894 VDD_5V CDAC_0/SPDT_2/out 1.705394f
C1895 SARclkgen_0/PHIA SAR_validpin_0/AND2_1/Y 0.132812f
C1896 SAR_validpin_0/DFFR_0/a_n50_n400# SAR_validpin_0/DFFR_0/a_n420_n400# 0.115835f
C1897 SAR_validpin_0/DFFR_3/a_n420_n400# SAR_validpin_0/AND2_1/a_n100_1100# 1.94e-19
C1898 SAR_validpin_0/AND2_0/Y SAR_validpin_0/AND2_1/Y 3.315028f
C1899 SAR_validpin_0/DFFR_0/a_3210_n400# CDAC_0/Vout 0.001142f
C1900 SAR_validpin_0/DFFR_7/a_2600_n430# SAR_validpin_0/DFFR_7/a_450_n400# 0.002434f
C1901 SAR_validpin_0/OR2_2/A VDD1v8 1.495265f
C1902 strongarm_0/5v_pfet_1_1_0/D CLK_comp 0.01838f
C1903 RST_N SAR_validpin_0/DFFR_4/a_90_n400# 0.056267f
C1904 SAR_validpin_0/DFFR_4/a_1310_n400# SAR_validpin_0/DFFR_4/a_n420_n400# 0.001016f
C1905 VDD1v8 SAR_validpin_0/2_1_MUX_2/a_n1230_n310# 0.273249f
C1906 SAR_validpin_0/DFFR_0/a_2090_n400# shift1v8to5_3/A 8.74e-20
C1907 SAR_validpin_0/DFFS_0/a_2090_n400# SAR_validpin_0/DFFR_8/a_90_n400# 2.78e-19
C1908 SAR_validpin_0/OR2_1/a_n80_n540# SAR_validpin_0/DFFR_0/a_2090_n400# 6.47e-19
C1909 SAR_validpin_0/AND2_1/a_n100_1100# SAR_validpin_0/OR2_0/a_n80_n540# 2.86e-21
C1910 SARclkgen_0/PHIB SAR_validpin_0/DFFR_1/a_2600_n430# 0.054685f
C1911 SAR_validpin_0/DFFS_0/a_600_n400# CDAC_0/Vout 0.009736f
C1912 SAR_validpin_0/DFFR_4/a_n50_n400# SAR_validpin_0/OR2_0/B 3.23e-20
C1913 SAR_validpin_0/DFFS_0/a_450_n400# CDAC_0/SPDT_3/out 0.004985f
C1914 SAR_validpin_0/DFFR_4/a_n50_n400# ADC_OUT1 0.01486f
C1915 RST_N SAR_validpin_0/DFFRR_0/a_450_n400# 0.294772f
C1916 SAR_validpin_0/DFFR_7/a_n420_n400# SAR_validpin_0/DFFRR_0/a_n560_n400# 2.37e-20
C1917 SARclkgen_0/PHIB SAR_validpin_0/DFFR_7/a_n420_n400# 0.662417f
C1918 SAR_validpin_0/DFFR_3/a_n420_n400# SAR_validpin_0/DFFR_3/a_2090_n400# 1.11e-20
C1919 SAR_validpin_0/DFFRR_1/D SAR_validpin_0/DFFRR_1/a_450_n400# 0.00587f
C1920 SAR_validpin_0/OR2_1/A SAR_validpin_0/DFFRR_0/a_2600_n430# 0.827995f
C1921 SARclkgen_0/PHIB NOT5V_0/Y 0.005025f
C1922 SAR_validpin_0/DFFR_3/D shift5to1v8_0/Y 0.001333f
C1923 SAR_validpin_0/DFFR_8/a_n50_n400# SAR_validpin_0/DFFR_8/a_2600_n430# 0.101474f
C1924 SAR_validpin_0/DFFR_1/a_1310_n400# SAR_validpin_0/DFFR_1/a_n50_n400# 0.006175f
C1925 SAR_validpin_0/DFFR_1/a_n420_n400# shift5to1v8_0/Y 3.16e-19
C1926 SAR_validpin_0/OR2_0/A SAR_validpin_0/DFFR_1/a_90_n400# 4.59e-21
C1927 SAR_validpin_0/AND2_1/a_90_n200# SAR_validpin_0/DFFRR_1/a_450_n400# 4.07e-19
C1928 SAR_validpin_0/DFFR_6/a_90_n400# shift1v8to5_1/A 2.43e-19
C1929 shift1v8to5_2/5v_pfet_1_2_2/D CDAC_0/Vcm 1.76e-20
C1930 SAR_validpin_0/OR2_1/A shift1v8to5_2/A 0.023106f
C1931 SAR_validpin_0/DFFR_7/a_n50_n400# SAR_validpin_0/OR2_2/B 0.005513f
C1932 SAR_validpin_0/DFFS_0/a_n420_n400# SAR_validpin_0/DFFS_0/a_450_n400# 0.329882f
C1933 SAR_validpin_0/DFFR_8/a_2600_n430# SAR_validpin_0/DFFS_0/a_90_n400# 9.75e-20
C1934 SAR_validpin_0/OR2_2/A SAR_validpin_0/DFFR_7/a_90_n400# 0.052709f
C1935 SARclkgen_0/PHIA CDAC_0/b2 0.00102f
C1936 VALID SAR_validpin_0/AND2_1/Y 8.65e-19
C1937 SAR_validpin_0/DFFS_0/a_600_n400# SAR_validpin_0/DFFR_0/a_90_n400# 3.44e-19
C1938 SAR_validpin_0/DFFR_0/a_n50_n400# SAR_validpin_0/DFFR_1/a_n50_n400# 0.001519f
C1939 SAR_validpin_0/2_1_MUX_2/a_n1230_n310# SAR_validpin_0/DFFR_7/a_90_n400# 0.002383f
C1940 SAR_validpin_0/DFFRR_0/a_2550_720# SAR_validpin_0/DFFRR_0/a_2090_n400# 0.011347f
C1941 shift5to1v8_0/Y VDD1v8 2.538053f
C1942 shift1v8to5_0/A CDAC_0/Vout 0.078953f
C1943 SAR_validpin_0/DFFR_5/a_2550_720# VDD_5V 8.67e-19
C1944 VDD_5V SAR_validpin_0/AND2_1/Y 0.009723f
C1945 shift1v8to5_1/A SAR_validpin_0/DFFR_1/a_90_n400# 0.055458f
C1946 SARclkgen_0/PHIB SAR_validpin_0/DFFR_1/a_2090_n400# 0.13513f
C1947 SAR_validpin_0/DFFS_0/a_n50_n400# CDAC_0/SPDT_3/out 2.5e-19
C1948 SAR_validpin_0/AND2_2/a_90_n200# shift1v8to5_0/A 0.001048f
C1949 SAR_validpin_0/DFFR_1/a_1310_n400# SAR_validpin_0/DFFR_1/a_n420_n400# 0.001016f
C1950 SRLatch5V_0/NQ CDAC_0/b3 5.62e-21
C1951 CDAC_0/b3 CDAC_0/Vout 1.555977f
C1952 SAR_validpin_0/DFFRR_1/a_350_n430# SAR_validpin_0/DFFRR_1/a_2090_n400# 0.001602f
C1953 SARclkgen_0/AND2_1/a_90_n200# SARclkgen_0/AND2_1/a_n100_1100# 0.011051f
C1954 SAR_validpin_0/DFFR_0/a_n50_n400# SAR_validpin_0/DFFR_0/a_1310_n400# 0.006175f
C1955 SAR_validpin_0/DFFR_3/a_2550_n400# RST_N 7.85e-19
C1956 SAR_validpin_0/DFFR_8/a_2600_n430# SAR_validpin_0/DFFR_8/a_2090_n400# 0.593043f
C1957 SAR_validpin_0/DFFRR_1/a_1460_n400# SAR_validpin_0/DFFRR_1/a_350_n430# 0.015634f
C1958 shift1v8to5_4/5v_pfet_1_2_0/D CLK 1.82e-19
C1959 SAR_validpin_0/DFFR_0/a_n50_n400# SAR_validpin_0/DFFR_1/a_n420_n400# 1.51e-19
C1960 SAR_validpin_0/DFFS_0/a_2550_n400# SAR_validpin_0/DFFS_0/a_600_n400# 0.006441f
C1961 RST_N SAR_validpin_0/DFFRR_1/a_3210_n400# 0.005107f
C1962 SAR_validpin_0/DFFS_0/a_1130_520# SAR_validpin_0/DFFS_0/a_350_n430# 0.255613f
C1963 SAR_validpin_0/DFFS_0/a_n50_n400# SAR_validpin_0/DFFS_0/a_n420_n400# 0.264755f
C1964 SAR_validpin_0/DFFS_0/a_450_n400# SAR_validpin_0/OR2_2/B 0.285096f
C1965 SAR_validpin_0/DFFR_6/a_n50_n400# SAR_validpin_0/DFFR_6/a_1460_n400# 0.006584f
C1966 shift1v8to5_0/A SAR_validpin_0/DFFR_0/a_90_n400# 9.16e-19
C1967 shift5to1v8_0/Y SAR_validpin_0/DFFR_7/a_90_n400# 0.00705f
C1968 SAR_validpin_0/DFFR_2/a_n420_n400# SAR_validpin_0/DFFR_2/a_2600_n430# 4.26e-20
C1969 SARclkgen_0/PHIA SAR_validpin_0/DFFRR_1/a_2090_n400# 0.465417f
C1970 CLK5 CDAC_0/b2 2.922583f
C1971 SAR_validpin_0/DFFR_3/a_1460_n400# SAR_validpin_0/DFFR_3/a_350_n430# 0.015634f
C1972 SAR_validpin_0/DFFS_0/a_3210_n400# SARclkgen_0/PHIA 0.010778f
C1973 SAR_validpin_0/AND2_0/Y SAR_validpin_0/DFFRR_1/a_2090_n400# 0.002786f
C1974 SARclkgen_0/PHIA SAR_validpin_0/DFFRR_1/a_1460_n400# 0.003593f
C1975 SAR_validpin_0/DFFR_0/a_n50_n400# VDD1v8 0.438228f
C1976 VDD1v8 SARclkgen_0/AND2_1/a_n100_1100# 0.684384f
C1977 SAR_validpin_0/DFFR_2/a_1460_n400# SAR_validpin_0/DFFR_2/a_n50_n400# 0.006584f
C1978 SAR_validpin_0/DFFRR_0/D SAR_validpin_0/DFFRR_0/a_n340_n430# 0.343388f
C1979 CDAC_0/SPDT_0/out Vin 2.865982f
C1980 SAR_validpin_0/OR2_2/A SAR_validpin_0/AND2_1/Y 0.391794f
C1981 SAR_validpin_0/AND2_0/Y SAR_validpin_0/DFFR_4/a_2600_n430# 0.133119f
C1982 SAR_validpin_0/DFFR_2/a_350_n430# SAR_validpin_0/DFFR_2/a_2090_n400# 0.001602f
C1983 VDD_5V CDAC_0/b2 3.405079f
C1984 SAR_validpin_0/AND2_0/a_n100_1100# SAR_validpin_0/DFFR_1/a_2600_n430# 0.006406f
C1985 VDD1v8 ADC_OUT0 0.212616f
C1986 CDAC_0/SPDT_4/out SARclkgen_0/PHIA 0.005859f
C1987 RST_N shift1v8to5_5/5v_pfet_1_2_2/D 0.17326f
C1988 SAR_validpin_0/DFFR_5/a_3210_n400# RST_N 0.004852f
C1989 RST_N SAR_validpin_0/DFFRR_1/a_450_n400# 0.294742f
C1990 SRLatch5V_0/NQ SARclkgen_0/PHIB 0.113961f
C1991 shift1v8to5_1/A SAR_validpin_0/DFFR_2/a_n420_n400# 0.072319f
C1992 SAR_validpin_0/DFFR_0/a_350_n430# SAR_validpin_0/DFFR_0/a_2090_n400# 0.001602f
C1993 SARclkgen_0/PHIB CDAC_0/Vout 0.049096f
C1994 SRLatch5V_0/NAND5v_0/5v_nfet_1_2_1/D CDAC_0/b2 0.003333f
C1995 SAR_validpin_0/DFFR_8/a_1130_520# shift1v8to5_1/A 0.004484f
C1996 SAR_validpin_0/DFFR_4/a_n420_n400# SAR_validpin_0/DFFR_4/a_1130_520# 0.088465f
C1997 SARclkgen_0/AND2_0/a_n100_1100# CLK_comp 0.015042f
C1998 SAR_validpin_0/2_1_MUX_0/a_n1230_n310# SAR_validpin_0/DFFRR_1/a_n930_n400# 0.016476f
C1999 SAR_validpin_0/DFFR_7/a_2090_n400# SAR_validpin_0/DFFRR_0/a_2600_n430# 3.11e-20
C2000 SAR_validpin_0/DFFR_7/a_2600_n430# SAR_validpin_0/DFFRR_0/a_2090_n400# 3.11e-20
C2001 CDAC_0/b1 VDD1v8 3.007736f
C2002 shift1v8to5_2/5v_pfet_1_2_2/D CDAC_0/b0 2.02e-20
C2003 VDD1v8 SAR_validpin_0/DFFR_2/a_90_n400# 0.468058f
C2004 SAR_validpin_0/OR2_1/B SAR_validpin_0/DFFR_0/a_1460_n400# 2.74e-19
C2005 shift1v8to5_1/A SAR_validpin_0/DFFS_0/a_600_n400# 0.083369f
C2006 CDAC_0/SPDT_0/out shift1v8to5_1/5v_pfet_1_2_0/D 3.1e-19
C2007 shift1v8to5_2/5v_pfet_1_2_2/D SRLatch5V_0/Q 5.39e-19
C2008 SAR_validpin_0/DFFR_6/a_n50_n400# SAR_validpin_0/OR2_1/A 2.84e-20
C2009 SARclkgen_0/PHIA SAR_validpin_0/DFFR_1/a_2550_n400# 0.003115f
C2010 shift1v8to5_1/A SAR_validpin_0/DFFRR_0/D 0.162467f
C2011 SAR_validpin_0/AND2_0/a_n100_1100# SAR_validpin_0/DFFR_1/a_2090_n400# 1.14e-20
C2012 SAR_validpin_0/2_1_MUX_0/a_n1230_n310# SARclkgen_0/PHIB 0.022574f
C2013 SAR_validpin_0/DFFR_4/a_n50_n400# SAR_validpin_0/DFFR_4/a_3210_n400# 2.5e-19
C2014 SAR_validpin_0/DFFR_2/a_350_n430# VDD1v8 1.26264f
C2015 SAR_validpin_0/DFFR_4/a_2600_n430# VDD_5V 0.041948f
C2016 SAR_validpin_0/OR2_1/A SAR_validpin_0/DFFRR_0/a_2550_720# 0.001284f
C2017 SAR_validpin_0/OR2_1/A SAR_validpin_0/OR2_1/B 2.163989f
C2018 SAR_validpin_0/OR2_0/A shift1v8to5_0/A 0.072478f
C2019 SARclkgen_0/PHIB SAR_validpin_0/DFFR_0/a_90_n400# 0.633556f
C2020 NOT5V_0/Y shift1v8to5_1/5v_pfet_1_2_2/D 0.003672f
C2021 SAR_validpin_0/DFFR_2/a_450_n400# CDAC_0/Vcm 0.002134f
C2022 CLK5 CDAC_0/SPDT_4/out 2.919837f
C2023 SAR_validpin_0/DFFRR_1/a_1310_n400# SAR_validpin_0/DFFRR_1/a_n930_n400# 0.001016f
C2024 SAR_validpin_0/DFFR_0/a_450_n400# SAR_validpin_0/DFFR_0/a_1130_520# 0.171763f
C2025 CDAC_0/b1 CDAC_0/SPDT_2/out 1.10691f
C2026 SAR_validpin_0/DFFR_6/a_90_n400# RST_N 0.060068f
C2027 SAR_validpin_0/DFFR_3/a_2550_720# SAR_validpin_0/DFFR_3/a_2090_n400# 0.011347f
C2028 VDD_5V CDAC_0/SPDT_4/out 1.755819f
C2029 SAR_validpin_0/DFFR_8/a_1460_n400# SAR_validpin_0/DFFR_8/a_n420_n400# 0.001621f
C2030 shift1v8to5_1/A shift1v8to5_0/A 0.093458f
C2031 SAR_validpin_0/DFFR_8/a_450_n400# SAR_validpin_0/DFFR_8/a_n50_n400# 0.818995f
C2032 SAR_validpin_0/DFFR_1/a_2090_n400# SAR_validpin_0/DFFR_1/a_2600_n430# 0.594661f
C2033 SAR_validpin_0/DFFR_7/a_350_n430# SAR_validpin_0/OR2_2/B 1.71e-19
C2034 SAR_validpin_0/DFFRR_1/D SAR_validpin_0/DFFRR_0/D 0.01011f
C2035 SARclkgen_0/PHIB SAR_validpin_0/DFFRR_1/a_1310_n400# 0.005571f
C2036 CLK5 SAR_validpin_0/DFFR_1/a_2550_n400# 5.58e-20
C2037 shift1v8to5_1/A CDAC_0/b3 0.121294f
C2038 SAR_validpin_0/OR2_1/B SAR_validpin_0/DFFRR_1/a_n560_n400# 1.22e-19
C2039 SAR_validpin_0/DFFR_3/a_1460_n400# SAR_validpin_0/DFFR_4/a_1130_520# 2.11e-19
C2040 RST_N SAR_validpin_0/DFFR_1/a_90_n400# 0.097485f
C2041 shift5to1v8_0/5v_pfet_1_2_1/G shift1v8to5_3/A 0.001575f
C2042 SAR_validpin_0/DFFR_6/a_n420_n400# SAR_validpin_0/DFFR_5/a_n50_n400# 2.37e-20
C2043 CDAC_0/SPDT_4/out SAR_validpin_0/DFFR_1/a_350_n430# 0.007482f
C2044 SAR_validpin_0/OR2_0/B SAR_validpin_0/DFFRR_1/a_n340_n430# 0.023906f
C2045 SAR_validpin_0/OR2_0/A SAR_validpin_0/DFFRR_1/a_n930_n400# 0.038527f
C2046 SAR_validpin_0/DFFR_6/a_1310_n400# SAR_validpin_0/DFFR_5/a_1130_520# 2.11e-19
C2047 SAR_validpin_0/DFFRR_1/a_n560_n400# SAR_validpin_0/DFFRR_1/a_1130_520# 0.003341f
C2048 SAR_validpin_0/DFFRR_0/a_n560_n400# SAR_validpin_0/DFFRR_0/a_n340_n430# 0.166999f
C2049 shift5to1v8_0/Y CDAC_0/b2 0.002076f
C2050 shift1v8to5_1/A SAR_validpin_0/DFFRR_0/a_1130_520# 0.003934f
C2051 SAR_validpin_0/AND2_2/a_n100_1100# SAR_validpin_0/DFFR_3/D 0.306624f
C2052 SARclkgen_0/PHIB SAR_validpin_0/DFFRR_0/a_n340_n430# 0.273259f
C2053 SAR_validpin_0/DFFR_2/a_1130_520# SAR_validpin_0/DFFR_3/a_350_n430# 4.7e-20
C2054 SAR_validpin_0/AND2_2/a_n100_1100# SAR_validpin_0/DFFR_1/a_n420_n400# 0.003697f
C2055 SAR_validpin_0/DFFR_2/a_350_n430# SAR_validpin_0/DFFR_3/a_1130_520# 4.7e-20
C2056 SAR_validpin_0/DFFS_0/a_350_n430# SARclkgen_0/PHIA 0.605986f
C2057 SARclkgen_0/PHIA SAR_validpin_0/DFFR_1/a_1130_520# 6.4e-19
C2058 SARclkgen_0/AND2_0/A CLK 0.408531f
C2059 SAR_validpin_0/DFFR_7/a_1310_n400# SAR_validpin_0/DFFRR_0/a_1130_520# 2.11e-19
C2060 SAR_validpin_0/DFFR_6/a_1130_520# SAR_validpin_0/DFFR_5/a_n420_n400# 3.28e-20
C2061 SARclkgen_0/PHIB SAR_validpin_0/DFFR_2/a_2600_n430# 4.47e-19
C2062 SAR_validpin_0/DFFRR_0/a_1460_n400# SAR_validpin_0/DFFRR_0/a_450_n400# 0.010382f
C2063 SAR_validpin_0/DFFR_1/a_1460_n400# CDAC_0/Vout 7.38e-19
C2064 SAR_validpin_0/DFFR_6/a_n50_n400# SAR_validpin_0/DFFR_6/a_350_n430# 0.260805f
C2065 SAR_validpin_0/OR2_1/A SAR_validpin_0/OR2_0/a_n80_n540# 0.001195f
C2066 SAR_validpin_0/DFFRR_1/a_2600_n430# SAR_validpin_0/DFFR_3/D 0.00911f
C2067 SARclkgen_0/PHIB SAR_validpin_0/OR2_0/A 0.216741f
C2068 shift1v8to5_1/A SAR_validpin_0/DFFRR_1/a_n930_n400# 0.098672f
C2069 shift1v8to5_5/5v_pfet_1_2_0/D CLK5 0.263984f
C2070 SAR_validpin_0/AND2_1/a_90_n200# shift1v8to5_0/A 5.14e-20
C2071 SAR_validpin_0/AND2_2/a_n100_1100# VDD1v8 0.721475f
C2072 SAR_validpin_0/DFFR_8/a_450_n400# SAR_validpin_0/DFFR_8/a_2090_n400# 0.28571f
C2073 SAR_validpin_0/DFFR_0/a_1310_n400# SAR_validpin_0/DFFR_0/a_n420_n400# 0.001016f
C2074 SAR_validpin_0/OR2_0/B SAR_validpin_0/2_1_MUX_1/a_n1230_n310# 4.59e-20
C2075 SAR_validpin_0/OR2_1/A SAR_validpin_0/DFFR_7/a_2600_n430# 0.008523f
C2076 VDD1v8 SAR_validpin_0/DFFRR_1/a_n420_720# 0.619014f
C2077 SAR_validpin_0/DFFRR_0/a_n420_720# SAR_validpin_0/DFFRR_0/D 0.39899f
C2078 SARclkgen_0/AND2_1/B VDD1v8 0.43281f
C2079 shift1v8to5_5/5v_pfet_1_2_0/D VDD_5V 0.296838f
C2080 SAR_validpin_0/AND2_0/a_90_n200# SAR_validpin_0/DFFRR_1/a_2600_n430# 1.38e-19
C2081 shift5to1v8_0/Y SAR_validpin_0/DFFRR_1/a_2090_n400# 0.002093f
C2082 SAR_validpin_0/DFFRR_1/a_2600_n430# VDD1v8 1.010865f
C2083 shift1v8to5_1/A SAR_validpin_0/DFFRR_0/a_n560_n400# 0.056936f
C2084 SARclkgen_0/PHIB shift1v8to5_1/A 1.928128f
C2085 CDAC_0/Vout SAR_validpin_0/DFFR_1/a_2600_n430# 0.005361f
C2086 SARclkgen_0/PHIA SAR_validpin_0/OR2_2/a_n80_n540# 1.61e-19
C2087 shift5to1v8_0/Y SAR_validpin_0/DFFRR_1/a_1460_n400# 0.001777f
C2088 SAR_validpin_0/AND2_0/a_n100_1100# SAR_validpin_0/DFFR_3/a_450_n400# 3.52e-19
C2089 SAR_validpin_0/DFFR_2/a_350_n430# SAR_validpin_0/AND2_1/Y 1.85e-20
C2090 SAR_validpin_0/DFFR_6/a_n50_n400# SAR_validpin_0/DFFR_7/a_2090_n400# 5.34e-19
C2091 RST_N SAR_validpin_0/DFFR_2/a_n420_n400# 0.397961f
C2092 VDD1v8 SAR_validpin_0/DFFR_0/a_n420_n400# 0.495614f
C2093 shift1v8to5_1/5v_pfet_1_2_2/D CDAC_0/Vout 0.054749f
C2094 SAR_validpin_0/DFFR_8/a_1130_520# RST_N 0.430204f
C2095 SAR_validpin_0/DFFR_7/a_1310_n400# SARclkgen_0/PHIB 0.005794f
C2096 VDD_5V SAR_validpin_0/DFFR_1/a_1130_520# 0.002895f
C2097 CDAC_0/SPDT_1/out CDAC_0/SPDT_2/out 0.089071f
C2098 NOT5V_0/Y CDAC_0/Vout 18.936146f
C2099 SARclkgen_0/PHIB SAR_validpin_0/DFFS_0/a_1460_n400# 0.002283f
C2100 SAR_validpin_0/DFFRR_1/a_n560_n400# SAR_validpin_0/OR2_0/a_n80_n540# 3.4e-19
C2101 ADC_OUT3 ADC_OUT2 0.997481f
C2102 SAR_validpin_0/DFFR_5/a_90_n400# SAR_validpin_0/DFFR_5/a_n50_n400# 0.538805f
C2103 SAR_validpin_0/DFFRR_1/D SAR_validpin_0/DFFRR_1/a_n930_n400# 0.526211f
C2104 SAR_validpin_0/DFFR_0/a_2550_n400# SAR_validpin_0/DFFR_0/a_2090_n400# 0.006257f
C2105 SAR_validpin_0/DFFS_0/a_350_n430# VDD_5V 0.009019f
C2106 RST_N SAR_validpin_0/DFFR_5/a_350_n430# 0.211826f
C2107 SAR_validpin_0/DFFRR_0/a_n930_n400# VDD1v8 0.474073f
C2108 SAR_validpin_0/DFFR_8/a_2550_n400# SAR_validpin_0/DFFR_8/a_2090_n400# 0.006257f
C2109 SAR_validpin_0/OR2_1/A SAR_validpin_0/DFFR_0/a_2600_n430# 0.001029f
C2110 SAR_validpin_0/DFFR_6/a_n50_n400# SAR_validpin_0/DFFR_7/a_n50_n400# 0.001519f
C2111 RST_N SAR_validpin_0/DFFS_0/a_600_n400# 0.565764f
C2112 RST_N SAR_validpin_0/DFFRR_0/D 0.003797f
C2113 CDAC_0/b1 CDAC_0/b2 3.234545f
C2114 CDAC_0/Vout SAR_validpin_0/DFFR_1/a_2090_n400# 0.005497f
C2115 SAR_validpin_0/DFFR_3/D SAR_validpin_0/DFFR_1/a_n50_n400# 1.03e-20
C2116 SAR_validpin_0/DFFRR_1/D SARclkgen_0/PHIB 0.266173f
C2117 VDD_5V shift1v8to5_3/5v_pfet_1_2_0/D 0.273552f
C2118 SAR_validpin_0/DFFR_1/a_350_n430# SAR_validpin_0/DFFR_1/a_1130_520# 0.24593f
C2119 SAR_validpin_0/DFFR_1/a_n420_n400# SAR_validpin_0/DFFR_1/a_n50_n400# 0.115912f
C2120 NOT5V_0/Y SAR_validpin_0/DFFR_0/a_90_n400# 5.85e-20
C2121 SARclkgen_0/PHIA SAR_validpin_0/DFFR_7/a_1460_n400# 0.00384f
C2122 SAR_validpin_0/AND2_0/Y SAR_validpin_0/DFFR_4/a_1310_n400# 0.00392f
C2123 SAR_validpin_0/DFFR_7/D SAR_validpin_0/OR2_2/B 0.479477f
C2124 SAR_validpin_0/DFFR_0/a_n50_n400# SAR_validpin_0/DFFS_0/a_3210_n400# 2.41e-19
C2125 SAR_validpin_0/OR2_1/B SAR_validpin_0/DFFR_0/a_2090_n400# 0.283581f
C2126 SAR_validpin_0/DFFS_0/a_450_n400# SAR_validpin_0/DFFR_8/a_90_n400# 9.59e-20
C2127 SAR_validpin_0/DFFR_6/a_350_n430# SAR_validpin_0/DFFR_7/a_2600_n430# 3.16e-20
C2128 SARclkgen_0/AND2_0/B CLK_comp 0.008707f
C2129 SAR_validpin_0/DFFS_0/a_n50_n400# SAR_validpin_0/DFFR_8/a_n420_n400# 1.13e-20
C2130 SAR_validpin_0/DFFS_0/a_1130_520# SAR_validpin_0/DFFR_8/a_350_n430# 0.0021f
C2131 RST_N shift1v8to5_0/A 0.017751f
C2132 VDD1v8 SAR_validpin_0/DFFR_2/a_2090_n400# 0.918708f
C2133 VDD1v8 SAR_validpin_0/DFFR_1/a_n50_n400# 0.442615f
C2134 SAR_validpin_0/DFFR_3/D SAR_validpin_0/DFFR_1/a_n420_n400# 2.38e-20
C2135 SAR_validpin_0/DFFR_3/a_n50_n400# SAR_validpin_0/DFFR_3/a_1310_n400# 0.006175f
C2136 SAR_validpin_0/AND2_0/Y SAR_validpin_0/DFFR_3/a_350_n430# 0.071155f
C2137 SARclkgen_0/PHIA SAR_validpin_0/DFFR_0/a_1130_520# 6.4e-19
C2138 SAR_validpin_0/DFFR_0/a_n50_n400# CDAC_0/SPDT_4/out 0.003423f
C2139 shift1v8to5_1/A ADC_OUT2 0.155259f
C2140 SAR_validpin_0/DFFR_2/a_1460_n400# SAR_validpin_0/DFFR_2/a_1130_520# 0.002821f
C2141 SAR_validpin_0/DFFR_8/a_n50_n400# SAR_validpin_0/DFFS_0/a_2090_n400# 0.00154f
C2142 SAR_validpin_0/AND2_0/a_n100_1100# SAR_validpin_0/OR2_0/A 0.003369f
C2143 SAR_validpin_0/AND2_0/Y SAR_validpin_0/DFFR_5/a_n50_n400# 1.934879f
C2144 SAR_validpin_0/DFFS_0/a_2550_n400# NOT5V_0/Y 2.24e-20
C2145 SAR_validpin_0/AND2_2/a_n100_1100# SAR_validpin_0/AND2_1/Y 1.46e-19
C2146 SAR_validpin_0/OR2_0/B SAR_validpin_0/DFFRR_1/a_450_n400# 0.001745f
C2147 SAR_validpin_0/DFFR_4/a_2600_n430# SAR_validpin_0/DFFR_3/a_3210_n400# 9.33e-20
C2148 VDD1v8 SARclkgen_0/AND2_1/a_90_n200# 9.6e-19
C2149 SAR_validpin_0/DFFR_7/a_450_n400# SAR_validpin_0/DFFRR_0/a_450_n400# 0.018533f
C2150 SAR_validpin_0/AND2_0/a_90_n200# SAR_validpin_0/DFFR_3/D 0.002716f
C2151 RST_N SAR_validpin_0/DFFRR_0/a_1130_520# 0.430407f
C2152 SAR_validpin_0/DFFRR_0/a_n420_720# SAR_validpin_0/DFFRR_0/a_n560_n400# 0.252522f
C2153 SAR_validpin_0/DFFRR_0/a_n240_n400# SAR_validpin_0/DFFRR_0/a_450_n400# 2.93e-19
C2154 shift1v8to5_5/5v_pfet_1_2_0/D shift5to1v8_0/Y 2.38e-19
C2155 SAR_validpin_0/DFFR_3/D VDD1v8 0.644898f
C2156 SAR_validpin_0/DFFR_1/a_n420_n400# VDD1v8 0.504792f
C2157 SAR_validpin_0/DFFRR_0/a_n420_720# SARclkgen_0/PHIB 0.667035f
C2158 strongarm_0/clk shift1v8to5_4/5v_pfet_1_2_0/D 0.270077f
C2159 SAR_validpin_0/AND2_0/a_n100_1100# shift1v8to5_1/A 0.161307f
C2160 SAR_validpin_0/DFFR_7/a_2090_n400# SAR_validpin_0/DFFR_7/a_2600_n430# 0.594476f
C2161 SAR_validpin_0/DFFRR_1/a_2600_n430# SAR_validpin_0/AND2_1/Y 0.022217f
C2162 RST_N SAR_validpin_0/DFFRR_1/a_n930_n400# 0.185891f
C2163 SAR_validpin_0/AND2_0/a_90_n200# VDD1v8 9.87e-19
C2164 SAR_validpin_0/DFFR_5/a_2090_n400# SAR_validpin_0/DFFR_5/a_1130_520# 1.24e-20
C2165 SAR_validpin_0/OR2_2/A SAR_validpin_0/OR2_2/a_n80_n540# 0.534438f
C2166 SAR_validpin_0/DFFR_7/a_2600_n430# SAR_validpin_0/DFFR_7/a_n50_n400# 0.101518f
C2167 SAR_validpin_0/AND2_0/Y SAR_validpin_0/DFFR_5/a_1310_n400# 0.00392f
C2168 VDD1v8 SAR_validpin_0/DFFRR_0/a_3210_n400# 0.001604f
C2169 SAR_validpin_0/DFFR_6/a_450_n400# SAR_validpin_0/DFFR_6/a_n420_n400# 0.252386f
C2170 VDD_5V SAR_validpin_0/DFFR_0/a_1130_520# 9.97e-20
C2171 shift5to1v8_0/5v_pfet_1_2_1/G shift1v8to5_2/A 0.024861f
C2172 VDD_5V SAR_validpin_0/DFFR_5/a_n50_n400# 0.004497f
C2173 CDAC_0/SPDT_1/out CDAC_0/b2 1.003622f
C2174 shift1v8to5_1/A SAR_validpin_0/DFFR_1/a_2600_n430# 0.088229f
C2175 RST_N SAR_validpin_0/DFFRR_0/a_n560_n400# 0.171845f
C2176 SARclkgen_0/PHIA CLK 1.558968f
C2177 SARclkgen_0/PHIB RST_N 7.243452f
C2178 shift1v8to5_1/A shift1v8to5_1/5v_pfet_1_2_2/D 0.620269f
C2179 shift1v8to5_1/A SAR_validpin_0/DFFR_7/a_n420_n400# 2.38e-19
C2180 SAR_validpin_0/DFFR_4/a_n50_n400# SAR_validpin_0/DFFRR_1/a_n560_n400# 0.001519f
C2181 VDD1v8 SAR_validpin_0/DFFR_1/a_2550_720# 0.014691f
C2182 shift1v8to5_1/A NOT5V_0/Y 0.175742f
C2183 SAR_validpin_0/DFFR_6/a_1460_n400# SAR_validpin_0/DFFR_5/a_1130_520# 2.11e-19
C2184 SAR_validpin_0/DFFR_7/a_2550_720# RST_N 0.01104f
C2185 SAR_validpin_0/DFFR_1/a_1310_n400# SAR_validpin_0/DFFR_1/a_1130_520# 0.002821f
C2186 SAR_validpin_0/DFFR_0/a_450_n400# CDAC_0/SPDT_3/out 0.002612f
C2187 strongarm_0/5v_pfet_1_1_3/D shift1v8to5_2/5v_pfet_1_2_2/D 0.003671f
C2188 SAR_validpin_0/DFFR_7/a_1310_n400# SAR_validpin_0/DFFR_7/a_n420_n400# 0.001016f
C2189 SAR_validpin_0/DFFR_4/a_2550_720# VDD1v8 0.013971f
C2190 SAR_validpin_0/OR2_1/B SAR_validpin_0/DFFR_1/a_450_n400# 0.049269f
C2191 SAR_validpin_0/DFFR_0/a_90_n400# CDAC_0/Vout 0.003225f
C2192 SAR_validpin_0/OR2_0/B SAR_validpin_0/DFFR_1/a_90_n400# 0.00229f
C2193 SAR_validpin_0/DFFR_5/a_n420_n400# SAR_validpin_0/DFFRR_0/a_2090_n400# 0.010629f
C2194 VDD1v8 SAR_validpin_0/DFFR_5/a_1460_n400# 9.65e-19
C2195 VDD1v8 SAR_validpin_0/DFFR_7/a_90_n400# 0.413086f
C2196 SAR_validpin_0/DFFS_0/a_1460_n400# NOT5V_0/Y 2.24e-20
C2197 SAR_validpin_0/OR2_2/A SAR_validpin_0/DFFR_7/a_1460_n400# 0.004487f
C2198 strongarm_0/5v_pfet_1_1_0/D CDAC_0/b3 9.47e-20
C2199 shift1v8to5_1/A SAR_validpin_0/DFFR_1/a_2090_n400# 0.050906f
C2200 SAR_validpin_0/DFFR_0/a_450_n400# shift1v8to5_3/A 5.74e-19
C2201 SAR_validpin_0/DFFR_5/a_2090_n400# SAR_validpin_0/DFFR_5/a_n420_n400# 1.11e-20
C2202 SAR_validpin_0/DFFR_4/a_450_n400# SAR_validpin_0/DFFR_4/a_n420_n400# 0.252386f
C2203 SAR_validpin_0/AND2_0/Y SAR_validpin_0/DFFR_4/a_1130_520# 0.002144f
C2204 VDD1v8 SAR_validpin_0/DFFR_3/a_1130_520# 0.557791f
C2205 shift5to1v8_0/5v_pfet_1_2_1/G SRLatch5V_0/R 0.004769f
C2206 VDD1v8 SAR_validpin_0/DFFR_5/a_450_n400# 0.517877f
C2207 SAR_validpin_0/DFFS_0/a_2550_n400# CDAC_0/Vout 7.65e-19
C2208 CLK5 CLK 0.441364f
C2209 SAR_validpin_0/DFFR_2/a_1460_n400# SARclkgen_0/PHIA 0.003792f
C2210 SAR_validpin_0/DFFR_0/a_2090_n400# SAR_validpin_0/DFFR_0/a_2600_n430# 0.570512f
C2211 CLK5 Vin 8.402202f
C2212 SAR_validpin_0/DFFR_7/a_1130_520# SAR_validpin_0/DFFRR_0/a_1310_n400# 2.11e-19
C2213 SAR_validpin_0/OR2_2/A SAR_validpin_0/DFFR_5/a_n50_n400# 2.84e-20
C2214 SAR_validpin_0/DFFR_3/a_2550_n400# SAR_validpin_0/DFFR_3/a_2090_n400# 0.006257f
C2215 VDD_5V CLK 0.733002f
C2216 SAR_validpin_0/DFFS_0/a_1130_520# SAR_validpin_0/DFFS_0/a_n420_n400# 0.104224f
C2217 SARclkgen_0/PHIA SAR_validpin_0/DFFR_8/a_350_n430# 0.070561f
C2218 SAR_validpin_0/DFFR_3/D SAR_validpin_0/AND2_1/Y 0.311984f
C2219 VDD_5V Vin 3.483125f
C2220 SAR_validpin_0/DFFR_8/a_2600_n430# shift1v8to5_0/A 0.017792f
C2221 SAR_validpin_0/AND2_1/a_n100_1100# SAR_validpin_0/DFFRR_1/a_450_n400# 5.96e-19
C2222 SAR_validpin_0/DFFRR_1/a_2600_n430# SAR_validpin_0/DFFRR_1/a_2090_n400# 0.594661f
C2223 SAR_validpin_0/DFFR_6/a_n420_n400# SAR_validpin_0/DFFR_6/a_2600_n430# 4.26e-20
C2224 shift1v8to5_3/5v_pfet_1_2_2/D shift1v8to5_0/5v_pfet_1_2_2/D 0.007713f
C2225 SAR_validpin_0/DFFR_0/a_n50_n400# SAR_validpin_0/OR2_2/a_n80_n540# 8.79e-19
C2226 RST_N ADC_OUT2 0.440257f
C2227 SAR_validpin_0/DFFRR_0/a_2090_n400# SAR_validpin_0/DFFRR_0/a_450_n400# 0.28571f
C2228 SAR_validpin_0/AND2_0/a_90_n200# SAR_validpin_0/AND2_1/Y 0.009041f
C2229 SAR_validpin_0/DFFR_0/a_450_n400# SAR_validpin_0/OR2_2/B 0.092731f
C2230 SAR_validpin_0/DFFR_1/a_450_n400# SAR_validpin_0/OR2_0/a_n80_n540# 2.26e-19
C2231 SAR_validpin_0/DFFR_5/a_2550_720# VDD1v8 0.013971f
C2232 SAR_validpin_0/DFFR_5/a_450_n400# SAR_validpin_0/DFFR_5/a_1460_n400# 0.010382f
C2233 SAR_validpin_0/DFFR_2/a_2600_n430# SAR_validpin_0/DFFR_2/a_3210_n400# 0.011304f
C2234 VDD1v8 SAR_validpin_0/AND2_1/Y 2.823749f
C2235 CDAC_0/b1 shift1v8to5_3/5v_pfet_1_2_0/D 0.013792f
C2236 SAR_validpin_0/AND2_2/a_90_n200# SAR_validpin_0/OR2_0/A 8.7e-20
C2237 SAR_validpin_0/DFFR_2/a_n420_n400# SAR_validpin_0/OR2_0/B 0.172967f
C2238 SAR_validpin_0/DFFR_7/a_1130_520# SAR_validpin_0/DFFRR_0/a_450_n400# 9.74e-20
C2239 CDAC_0/SPDT_4/out SAR_validpin_0/DFFR_0/a_n420_n400# 5.35e-19
C2240 strongarm_0/clk SARclkgen_0/AND2_0/A 0.096758f
C2241 SAR_validpin_0/AND2_0/a_n100_1100# RST_N 0.154336f
C2242 SAR_validpin_0/DFFRR_0/a_n420_720# SAR_validpin_0/DFFR_7/a_n420_n400# 3.44e-21
C2243 VDD_5V shift1v8to5_1/5v_pfet_1_2_0/D 0.078471f
C2244 shift1v8to5_1/A CDAC_0/Vout 0.832335f
C2245 SAR_validpin_0/DFFRR_1/a_2550_720# SAR_validpin_0/OR2_0/A 0.001284f
C2246 SAR_validpin_0/DFFR_4/a_n420_n400# SAR_validpin_0/DFFR_4/a_350_n430# 0.316282f
C2247 SAR_validpin_0/DFFRR_0/a_2550_n400# SARclkgen_0/PHIA 0.001071f
C2248 SAR_validpin_0/AND2_2/a_90_n200# shift1v8to5_1/A 0.007301f
C2249 SAR_validpin_0/DFFRR_0/D SAR_validpin_0/OR2_0/B 1.17e-19
C2250 SAR_validpin_0/AND2_0/Y SAR_validpin_0/DFFRR_0/a_2550_n400# 2.18e-19
C2251 SAR_validpin_0/2_1_MUX_0/a_n1230_n310# SAR_validpin_0/OR2_0/A 0.199393f
C2252 VALID SAR_validpin_0/DFFR_8/a_350_n430# 1.88e-19
C2253 SAR_validpin_0/DFFR_6/a_450_n400# SAR_validpin_0/AND2_0/Y 0.343737f
C2254 shift1v8to5_1/A SAR_validpin_0/DFFR_2/a_3210_n400# 0.007057f
C2255 SAR_validpin_0/DFFS_0/a_1460_n400# CDAC_0/Vout 5.79e-19
C2256 SAR_validpin_0/OR2_1/A SAR_validpin_0/DFFR_5/a_n420_n400# 0.09791f
C2257 SAR_validpin_0/DFFR_5/a_1460_n400# SAR_validpin_0/AND2_1/Y 0.009764f
C2258 RST_N SAR_validpin_0/DFFR_1/a_2600_n430# 0.589364f
C2259 SAR_validpin_0/DFFR_7/a_2600_n430# SAR_validpin_0/DFFR_7/a_350_n430# 2.63e-19
C2260 SAR_validpin_0/DFFR_1/a_450_n400# SAR_validpin_0/DFFR_0/a_2600_n430# 9.02e-21
C2261 SARclkgen_0/PHIB SAR_validpin_0/DFFR_1/a_3210_n400# 4.29e-19
C2262 SAR_validpin_0/2_1_MUX_0/a_n1230_n310# shift1v8to5_1/A 1.35e-19
C2263 SARclkgen_0/PHIB SAR_validpin_0/DFFR_8/a_2600_n430# 9.34e-19
C2264 VDD1v8 CDAC_0/b2 3.209821f
C2265 SAR_validpin_0/OR2_1/A SAR_validpin_0/DFFRR_0/a_1310_n400# 0.003993f
C2266 SAR_validpin_0/DFFR_8/a_n50_n400# SAR_validpin_0/DFFR_8/a_1460_n400# 0.006584f
C2267 SAR_validpin_0/DFFR_3/a_1130_520# SAR_validpin_0/AND2_1/Y 0.115688f
C2268 RST_N NOT5V_0/Y 0.190985f
C2269 shift1v8to5_1/A SAR_validpin_0/DFFR_0/a_90_n400# 0.033441f
C2270 shift1v8to5_1/A SAR_validpin_0/DFFR_3/a_450_n400# 0.006788f
C2271 SAR_validpin_0/OR2_0/A SAR_validpin_0/DFFRR_1/a_n240_n400# 0.004293f
C2272 RST_N SAR_validpin_0/DFFR_7/a_n420_n400# 0.191415f
C2273 SAR_validpin_0/DFFR_0/a_n50_n400# SAR_validpin_0/DFFR_0/a_1130_520# 0.003341f
C2274 SAR_validpin_0/DFFR_0/a_450_n400# SAR_validpin_0/DFFR_0/a_350_n430# 0.980343f
C2275 SAR_validpin_0/DFFR_2/a_n50_n400# CDAC_0/Vcm 9.95e-20
C2276 SAR_validpin_0/OR2_0/A SAR_validpin_0/DFFRR_1/a_1310_n400# 0.003993f
C2277 SAR_validpin_0/DFFR_5/a_450_n400# SAR_validpin_0/AND2_1/Y 0.793639f
C2278 SAR_validpin_0/OR2_0/B shift1v8to5_0/A 0.199029f
C2279 SRLatch5V_0/S SARclkgen_0/AND2_0/A 0.008731f
C2280 SAR_validpin_0/OR2_1/A SAR_validpin_0/DFFRR_1/a_n340_n430# 8.96e-20
C2281 SAR_validpin_0/DFFRR_0/a_1460_n400# SAR_validpin_0/DFFRR_0/a_1130_520# 0.002821f
C2282 CDAC_0/SPDT_4/out SAR_validpin_0/DFFR_1/a_n50_n400# 0.002015f
C2283 shift5to1v8_0/Y CLK 2.99e-19
C2284 SAR_validpin_0/DFFR_3/D SAR_validpin_0/DFFRR_1/a_2090_n400# 0.008479f
C2285 shift1v8to5_4/5v_pfet_1_2_2/D shift1v8to5_4/5v_pfet_1_2_0/D 0.023009f
C2286 SAR_validpin_0/AND2_2/a_n100_1100# SAR_validpin_0/DFFR_1/a_1130_520# 0.002332f
C2287 SAR_validpin_0/DFFR_3/D SAR_validpin_0/DFFRR_1/a_1460_n400# 0.001369f
C2288 SAR_validpin_0/DFFR_8/a_450_n400# SAR_validpin_0/DFFR_8/a_1130_520# 0.171763f
C2289 VDD_5V SRLatch5V_0/NAND5v_1/5v_nfet_1_2_1/D 0.027329f
C2290 SAR_validpin_0/DFFR_6/a_450_n400# VALID 9.65e-19
C2291 SAR_validpin_0/DFFR_7/D SAR_validpin_0/OR2_1/B 5.11e-19
C2292 shift1v8to5_1/A SAR_validpin_0/DFFRR_1/a_n240_n400# 0.001032f
C2293 shift1v8to5_2/5v_pfet_1_2_0/D shift1v8to5_2/5v_pfet_1_2_2/D 0.023009f
C2294 SARclkgen_0/PHIA CDAC_0/SPDT_3/out 0.006236f
C2295 SAR_validpin_0/DFFR_6/a_450_n400# VDD_5V 0.012267f
C2296 shift1v8to5_1/A SAR_validpin_0/DFFRR_1/a_1310_n400# 6.97e-19
C2297 RST_N SAR_validpin_0/DFFR_1/a_2090_n400# 0.468684f
C2298 SAR_validpin_0/DFFR_4/a_2090_n400# shift1v8to5_1/A 2.59e-19
C2299 shift1v8to5_1/A ADC_OUT3 0.126014f
C2300 SAR_validpin_0/DFFR_2/a_90_n400# SAR_validpin_0/DFFR_3/a_350_n430# 6.99e-20
C2301 SAR_validpin_0/DFFRR_1/D SAR_validpin_0/2_1_MUX_0/a_n1230_n310# 1.160349f
C2302 SAR_validpin_0/DFFR_8/a_450_n400# SAR_validpin_0/DFFS_0/a_600_n400# 5.68e-20
C2303 VDD1v8 SAR_validpin_0/DFFRR_1/a_2090_n400# 0.934655f
C2304 CDAC_0/SPDT_4/out SAR_validpin_0/DFFR_1/a_n420_n400# 0.002312f
C2305 SAR_validpin_0/OR2_1/A SAR_validpin_0/DFFRR_0/a_450_n400# 0.159822f
C2306 shift1v8to5_1/A SAR_validpin_0/DFFRR_0/a_n340_n430# 0.316466f
C2307 SAR_validpin_0/DFFR_2/a_350_n430# SAR_validpin_0/DFFR_3/a_350_n430# 0.014677f
C2308 SAR_validpin_0/OR2_0/B SAR_validpin_0/DFFRR_1/a_n930_n400# 0.01354f
C2309 SAR_validpin_0/DFFR_4/a_2600_n430# VDD1v8 0.971182f
C2310 SAR_validpin_0/OR2_1/A SAR_validpin_0/2_1_MUX_1/a_n1230_n310# 0.326014f
C2311 CDAC_0/SPDT_0/out CDAC_0/Vcm 0.06098f
C2312 SARclkgen_0/PHIA SAR_validpin_0/OR2_1/a_n80_n540# 0.08573f
C2313 SARclkgen_0/PHIA shift1v8to5_3/A 0.305607f
C2314 SAR_validpin_0/DFFS_0/a_n420_n400# SARclkgen_0/PHIA 0.499047f
C2315 SAR_validpin_0/DFFRR_1/a_n560_n400# SAR_validpin_0/DFFRR_1/a_n340_n430# 0.166999f
C2316 SAR_validpin_0/DFFRR_0/a_1460_n400# SAR_validpin_0/DFFRR_0/a_n560_n400# 0.006485f
C2317 shift1v8to5_1/A SAR_validpin_0/DFFR_2/a_2600_n430# 0.960813f
C2318 SAR_validpin_0/DFFR_3/a_n420_n400# SAR_validpin_0/DFFR_3/a_90_n400# 0.438846f
C2319 SARclkgen_0/PHIB SAR_validpin_0/DFFRR_0/a_1460_n400# 0.009764f
C2320 SAR_validpin_0/AND2_0/Y SAR_validpin_0/DFFR_6/a_2600_n430# 0.133119f
C2321 shift5to1v8_0/5v_pfet_1_2_1/G SRLatch5V_0/Q 6.13e-20
C2322 shift1v8to5_1/A SAR_validpin_0/OR2_0/A 0.493977f
C2323 SARclkgen_0/AND2_1/a_n100_1100# CLK 0.506963f
C2324 SAR_validpin_0/DFFR_0/a_450_n400# shift1v8to5_2/A 7.98e-20
C2325 CLK5 CDAC_0/SPDT_3/out 1.590919f
C2326 SARclkgen_0/PHIB SARclkgen_0/AND2_0/a_n100_1100# 0.490153f
C2327 SAR_validpin_0/DFFR_8/a_450_n400# shift1v8to5_0/A 0.014867f
C2328 SAR_validpin_0/DFFRR_0/a_2550_n400# SAR_validpin_0/OR2_2/A 7.48e-19
C2329 SARclkgen_0/PHIB SAR_validpin_0/OR2_0/B 0.684466f
C2330 SAR_validpin_0/DFFR_6/a_450_n400# SAR_validpin_0/OR2_2/A 0.049038f
C2331 VDD_5V CDAC_0/SPDT_3/out 1.748113f
C2332 SAR_validpin_0/DFFR_0/a_450_n400# SAR_validpin_0/OR2_2/a_100_310# 0.001471f
C2333 strongarm_0/5v_pfet_1_1_0/D NOT5V_0/Y 0.009298f
C2334 shift1v8to5_0/5v_pfet_1_2_2/D shift1v8to5_0/A 0.842411f
C2335 VDD1v8 SAR_validpin_0/DFFR_1/a_2550_n400# 4.37e-19
C2336 SARclkgen_0/PHIA SAR_validpin_0/OR2_2/B 0.398495f
C2337 RST_N CDAC_0/Vout 0.068607f
C2338 SAR_validpin_0/AND2_0/a_n100_1100# SAR_validpin_0/DFFR_3/a_n50_n400# 3.66e-19
C2339 SAR_validpin_0/DFFR_8/a_3210_n400# SARclkgen_0/PHIA 9.34e-19
C2340 SARclkgen_0/AND2_0/A SRLatch5V_0/R 0.015333f
C2341 CDAC_0/b1 Vin 1.604945f
C2342 SAR_validpin_0/DFFS_0/a_n420_n400# VDD_5V 0.00575f
C2343 VALID SAR_validpin_0/DFFR_6/a_2600_n430# 0.001182f
C2344 shift1v8to5_1/A SAR_validpin_0/DFFS_0/a_1460_n400# 1.22e-19
C2345 VALID shift1v8to5_3/A 0.138321f
C2346 SAR_validpin_0/DFFR_1/a_n50_n400# SAR_validpin_0/DFFR_1/a_1130_520# 0.003341f
C2347 VDD_5V shift1v8to5_3/A 1.074313f
C2348 VDD_5V SAR_validpin_0/DFFR_6/a_2600_n430# 0.058263f
C2349 SAR_validpin_0/DFFRR_1/D SAR_validpin_0/OR2_0/A 0.374556f
C2350 SAR_validpin_0/DFFS_0/a_450_n400# SAR_validpin_0/DFFS_0/a_90_n400# 0.129103f
C2351 RST_N SAR_validpin_0/DFFR_2/a_3210_n400# 0.002008f
C2352 SAR_validpin_0/DFFR_8/a_2550_n400# shift1v8to5_0/A 0.00111f
C2353 SAR_validpin_0/AND2_1/a_90_n200# SAR_validpin_0/OR2_0/A 0.001302f
C2354 SAR_validpin_0/DFFR_3/a_n420_n400# SAR_validpin_0/DFFR_4/a_n420_n400# 0.010516f
C2355 SARclkgen_0/PHIA SAR_validpin_0/DFFR_8/a_1310_n400# 0.003566f
C2356 shift1v8to5_0/5v_pfet_1_2_0/D VDD_5V 0.09533f
C2357 SAR_validpin_0/AND2_1/a_n100_1100# shift1v8to5_0/A 6.11e-19
C2358 SAR_validpin_0/DFFR_1/a_3210_n400# SAR_validpin_0/DFFR_1/a_2600_n430# 0.011304f
C2359 SAR_validpin_0/DFFRR_1/a_2550_720# RST_N 0.011485f
C2360 SRLatch5V_0/NAND5v_0/5v_nfet_1_2_1/D shift1v8to5_3/A 3.71e-19
C2361 strongarm_0/clk SARclkgen_0/PHIA 0.121387f
C2362 shift1v8to5_5/5v_pfet_1_2_0/D VDD1v8 0.58821f
C2363 SAR_validpin_0/DFFR_7/a_450_n400# SAR_validpin_0/DFFRR_0/a_1130_520# 9.74e-20
C2364 SAR_validpin_0/DFFRR_1/D shift1v8to5_1/A 0.157073f
C2365 SAR_validpin_0/DFFR_3/D SAR_validpin_0/DFFR_1/a_1130_520# 0.004064f
C2366 SAR_validpin_0/AND2_0/Y SAR_validpin_0/DFFR_3/a_2600_n430# 0.133119f
C2367 SAR_validpin_0/DFFR_1/a_n420_n400# SAR_validpin_0/DFFR_1/a_1130_520# 0.088465f
C2368 RST_N SAR_validpin_0/DFFR_0/a_90_n400# 0.094422f
C2369 CDAC_0/b1 shift1v8to5_1/5v_pfet_1_2_0/D 0.00323f
C2370 RST_N SAR_validpin_0/DFFR_3/a_450_n400# 0.295402f
C2371 SAR_validpin_0/DFFRR_1/a_3210_n400# SAR_validpin_0/DFFRR_1/a_n560_n400# 2.5e-19
C2372 SAR_validpin_0/DFFRR_0/a_n420_720# SAR_validpin_0/DFFRR_0/a_n340_n430# 0.599641f
C2373 CLK5 SAR_validpin_0/OR2_2/B 2.97e-19
C2374 SAR_validpin_0/AND2_1/a_90_n200# shift1v8to5_1/A 0.005088f
C2375 SAR_validpin_0/AND2_1/Y SAR_validpin_0/DFFRR_1/a_2090_n400# 0.006176f
C2376 CDAC_0/SPDT_0/out CDAC_0/b0 0.439309f
C2377 SAR_validpin_0/DFFR_8/a_450_n400# SARclkgen_0/PHIB 0.79426f
C2378 VALID SAR_validpin_0/OR2_2/B 0.903501f
C2379 ADC_OUT1 ADC_OUT2 0.436345f
C2380 SAR_validpin_0/DFFR_4/a_2600_n430# SAR_validpin_0/AND2_1/Y 4.47e-19
C2381 VDD_5V SAR_validpin_0/OR2_2/B 0.020114f
C2382 SAR_validpin_0/DFFR_8/a_3210_n400# VALID 0.011043f
C2383 SAR_validpin_0/DFFR_5/a_90_n400# SAR_validpin_0/DFFRR_0/a_2600_n430# 2.37e-19
C2384 SAR_validpin_0/DFFS_0/a_350_n430# VDD1v8 0.861905f
C2385 SAR_validpin_0/DFFS_0/a_n50_n400# SAR_validpin_0/DFFS_0/a_90_n400# 0.556032f
C2386 SAR_validpin_0/DFFS_0/a_350_n430# SAR_validpin_0/DFFS_0/a_1310_n400# 0.006999f
C2387 VDD1v8 SAR_validpin_0/DFFR_1/a_1130_520# 0.556327f
C2388 SARclkgen_0/PHIB shift1v8to5_0/5v_pfet_1_2_2/D 0.006629f
C2389 SAR_validpin_0/OR2_2/A shift1v8to5_3/A 0.032605f
C2390 SAR_validpin_0/DFFR_0/a_1130_520# SAR_validpin_0/DFFR_0/a_n420_n400# 0.088465f
C2391 SARclkgen_0/PHIA SAR_validpin_0/DFFR_0/a_350_n430# 0.116178f
C2392 SAR_validpin_0/OR2_2/A SAR_validpin_0/OR2_1/a_n80_n540# 0.00126f
C2393 SAR_validpin_0/DFFR_2/a_1460_n400# SAR_validpin_0/DFFR_2/a_350_n430# 0.015634f
C2394 RST_N ADC_OUT3 0.381362f
C2395 SAR_validpin_0/DFFR_4/a_2090_n400# RST_N 0.472287f
C2396 SAR_validpin_0/AND2_0/a_n100_1100# SAR_validpin_0/OR2_0/B 0.045954f
C2397 SAR_validpin_0/DFFR_7/a_n50_n400# SAR_validpin_0/DFFRR_0/a_450_n400# 6.99e-20
C2398 SAR_validpin_0/DFFR_7/a_450_n400# SAR_validpin_0/DFFRR_0/a_n560_n400# 6.99e-20
C2399 strongarm_0/clk CLK5 0.248363f
C2400 VDD_5V strongarm_0/5v_nfet_1_1_3/S 0.140932f
C2401 SARclkgen_0/PHIB SAR_validpin_0/DFFR_7/a_450_n400# 0.795188f
C2402 SAR_validpin_0/DFFRR_1/a_450_n400# SAR_validpin_0/DFFRR_1/a_n560_n400# 0.805264f
C2403 SAR_validpin_0/AND2_0/Y SAR_validpin_0/DFFR_4/a_450_n400# 0.35235f
C2404 SAR_validpin_0/DFFRR_0/a_n240_n400# SAR_validpin_0/DFFRR_0/a_n560_n400# 0.010714f
C2405 RST_N SAR_validpin_0/DFFRR_0/a_n340_n430# 9.51e-19
C2406 VDD1v8 shift1v8to5_3/5v_pfet_1_2_0/D 0.607571f
C2407 VDD_5V SAR_validpin_0/DFFR_3/a_2600_n430# 0.041948f
C2408 SRLatch5V_0/S SARclkgen_0/PHIA 8.25e-19
C2409 SAR_validpin_0/DFFR_0/a_450_n400# SAR_validpin_0/OR2_1/B 0.006962f
C2410 SAR_validpin_0/DFFRR_0/a_n240_n400# SARclkgen_0/PHIB 0.004173f
C2411 SAR_validpin_0/DFFS_0/a_600_n400# SAR_validpin_0/DFFS_0/a_2090_n400# 0.708045f
C2412 SAR_validpin_0/DFFR_3/a_n420_n400# SAR_validpin_0/DFFR_3/a_1460_n400# 0.001621f
C2413 SAR_validpin_0/DFFRR_0/a_n420_720# shift1v8to5_1/A 0.12239f
C2414 strongarm_0/clk VDD_5V 6.226974f
C2415 SAR_validpin_0/DFFR_5/a_350_n430# SAR_validpin_0/DFFRR_0/a_2090_n400# 1.34e-19
C2416 strongarm_0/5v_pfet_1_1_0/D CDAC_0/Vout 0.067007f
C2417 SARclkgen_0/PHIB SAR_validpin_0/AND2_1/a_n100_1100# 0.464197f
C2418 RST_N SAR_validpin_0/DFFR_2/a_2600_n430# 0.666677f
C2419 CDAC_0/SPDT_1/out Vin 3.249527f
C2420 SAR_validpin_0/DFFR_5/a_2090_n400# SAR_validpin_0/DFFR_5/a_350_n430# 0.001602f
C2421 SAR_validpin_0/OR2_0/B SAR_validpin_0/DFFR_1/a_2600_n430# 0.765385f
C2422 VDD1v8 SAR_validpin_0/OR2_2/a_n80_n540# 0.454502f
C2423 SARclkgen_0/PHIA SAR_validpin_0/DFFS_0/a_2550_720# 6.21e-19
C2424 RST_N SAR_validpin_0/OR2_0/A 0.286304f
C2425 shift5to1v8_0/Y shift1v8to5_3/A 0.001797f
C2426 SAR_validpin_0/OR2_2/A SAR_validpin_0/OR2_2/B 0.986949f
C2427 SARclkgen_0/AND2_1/B CLK 1.034928f
C2428 shift5to1v8_0/Y SAR_validpin_0/OR2_1/a_n80_n540# 0.001709f
C2429 SAR_validpin_0/DFFR_6/a_n50_n400# SAR_validpin_0/DFFR_6/a_n420_n400# 0.115989f
C2430 SARclkgen_0/PHIA SAR_validpin_0/DFFRR_0/a_2600_n430# 0.133119f
C2431 SAR_validpin_0/2_1_MUX_2/a_n1230_n310# SAR_validpin_0/OR2_2/B 0.458745f
C2432 SARclkgen_0/AND2_0/a_n100_1100# NOT5V_0/Y 2.95e-19
C2433 SAR_validpin_0/AND2_0/Y SAR_validpin_0/DFFRR_0/a_2600_n430# 0.002481f
C2434 VDD_5V SAR_validpin_0/DFFR_0/a_350_n430# 0.011154f
C2435 ADC_OUT2 SAR_validpin_0/DFFR_6/a_2090_n400# 3.07e-20
C2436 SAR_validpin_0/DFFRR_0/a_n420_720# SAR_validpin_0/DFFRR_1/D 3.16e-19
C2437 SAR_validpin_0/DFFRR_0/a_350_n430# SAR_validpin_0/DFFRR_0/a_2600_n430# 2.63e-19
C2438 shift1v8to5_1/A RST_N 18.467005f
C2439 SRLatch5V_0/S CLK5 2.46e-20
C2440 SARclkgen_0/PHIA shift1v8to5_2/A 0.152855f
C2441 SAR_validpin_0/AND2_0/Y SAR_validpin_0/DFFR_5/a_2600_n430# 0.133119f
C2442 SAR_validpin_0/DFFR_0/a_n50_n400# CDAC_0/SPDT_3/out 1.06e-19
C2443 CDAC_0/SPDT_1/out shift1v8to5_1/5v_pfet_1_2_0/D 0.005752f
C2444 SARclkgen_0/PHIB SARclkgen_0/AND2_0/a_90_n200# 0.011876f
C2445 SAR_validpin_0/DFFR_4/a_1310_n400# VDD1v8 0.001032f
C2446 SAR_validpin_0/DFFR_3/D SAR_validpin_0/DFFR_3/a_350_n430# 0.218989f
C2447 SAR_validpin_0/DFFR_0/a_1310_n400# SAR_validpin_0/DFFR_0/a_1130_520# 0.002821f
C2448 SAR_validpin_0/OR2_0/B SAR_validpin_0/DFFR_1/a_2090_n400# 0.188591f
C2449 shift1v8to5_2/5v_pfet_1_2_2/D CDAC_0/b3 1.440216f
C2450 SRLatch5V_0/S VDD_5V 3.46559f
C2451 SARclkgen_0/PHIB SARclkgen_0/AND2_0/B 0.480538f
C2452 SAR_validpin_0/DFFR_4/a_n50_n400# SAR_validpin_0/DFFR_4/a_n420_n400# 0.115835f
C2453 shift5to1v8_0/Y SAR_validpin_0/OR2_2/B 0.336658f
C2454 SAR_validpin_0/DFFS_0/a_n420_n400# SAR_validpin_0/DFFR_0/a_n50_n400# 0.001519f
C2455 SAR_validpin_0/AND2_0/Y SAR_validpin_0/DFFR_4/a_350_n430# 0.093324f
C2456 VDD1v8 SAR_validpin_0/DFFR_3/a_350_n430# 1.265183f
C2457 SAR_validpin_0/DFFRR_0/a_2090_n400# SAR_validpin_0/DFFRR_0/a_1130_520# 1.24e-20
C2458 SAR_validpin_0/AND2_0/Y SAR_validpin_0/DFFR_6/a_2550_n400# 0.001071f
C2459 SAR_validpin_0/DFFR_6/a_90_n400# SAR_validpin_0/DFFR_6/a_350_n430# 0.349264f
C2460 VDD1v8 SAR_validpin_0/DFFR_5/a_n50_n400# 0.499566f
C2461 SAR_validpin_0/DFFRR_1/D RST_N 0.003757f
C2462 VDD1v8 SAR_validpin_0/DFFR_0/a_1130_520# 0.540239f
C2463 SARclkgen_0/PHIA SRLatch5V_0/R 0.002926f
C2464 shift5to1v8_0/5v_pfet_1_2_1/G CLK_comp 9.93e-20
C2465 SAR_validpin_0/AND2_1/a_90_n200# RST_N 5.15e-19
C2466 SAR_validpin_0/DFFR_5/a_n50_n400# SAR_validpin_0/DFFRR_0/a_3210_n400# 2.41e-19
C2467 SAR_validpin_0/DFFR_3/a_450_n400# SAR_validpin_0/DFFR_3/a_n50_n400# 0.819164f
C2468 SAR_validpin_0/DFFR_5/a_2600_n430# VDD_5V 0.041996f
C2469 VALID shift1v8to5_2/A 0.226852f
C2470 RST_N SAR_validpin_0/DFFR_5/a_2550_n400# 7.85e-19
C2471 VDD_5V shift1v8to5_2/A 1.366982f
C2472 SARclkgen_0/PHIA SAR_validpin_0/DFFR_8/a_n420_n400# 0.172816f
C2473 CDAC_0/b1 shift1v8to5_3/A 0.021161f
C2474 strongarm_0/clk shift5to1v8_0/Y 1.78e-19
C2475 SAR_validpin_0/AND2_0/a_n100_1100# SAR_validpin_0/AND2_1/a_n100_1100# 0.005207f
C2476 SARclkgen_0/PHIB SAR_validpin_0/DFFS_0/a_2090_n400# 0.418847f
C2477 RST_N SAR_validpin_0/DFFR_7/a_3210_n400# 0.005107f
C2478 RST_N SAR_validpin_0/DFFR_6/a_2550_720# 0.011717f
C2479 SAR_validpin_0/OR2_1/A SAR_validpin_0/DFFR_5/a_350_n430# 0.214171f
C2480 SAR_validpin_0/DFFR_4/a_1310_n400# SAR_validpin_0/DFFR_3/a_1130_520# 2.11e-19
C2481 SAR_validpin_0/DFFR_3/a_n420_n400# SAR_validpin_0/DFFR_2/a_1130_520# 3.28e-20
C2482 shift1v8to5_0/5v_pfet_1_2_0/D CDAC_0/b1 0.31561f
C2483 shift1v8to5_0/5v_pfet_1_2_2/D NOT5V_0/Y 0.003729f
C2484 SARclkgen_0/AND2_1/a_90_n200# CLK 9.16e-19
C2485 SAR_validpin_0/DFFR_2/a_450_n400# SAR_validpin_0/DFFR_2/a_n420_n400# 0.252386f
C2486 SAR_validpin_0/DFFRR_0/a_2090_n400# SAR_validpin_0/DFFRR_0/a_n560_n400# 0.596801f
C2487 SARclkgen_0/PHIB SAR_validpin_0/DFFRR_0/a_2090_n400# 2.44e-19
C2488 SAR_validpin_0/DFFR_0/a_n50_n400# SAR_validpin_0/OR2_2/B 0.166965f
C2489 SRLatch5V_0/NAND5v_0/5v_nfet_1_2_1/D shift1v8to5_2/A 0.024806f
C2490 SAR_validpin_0/DFFR_6/a_90_n400# SAR_validpin_0/DFFR_7/a_2090_n400# 0.001682f
C2491 SAR_validpin_0/DFFR_6/a_n420_n400# SAR_validpin_0/DFFR_7/a_2600_n430# 0.130292f
C2492 SARclkgen_0/PHIA SAR_validpin_0/DFFR_0/a_2550_n400# 0.003115f
C2493 SAR_validpin_0/OR2_1/A SAR_validpin_0/DFFRR_0/D 0.568736f
C2494 SAR_validpin_0/DFFR_5/a_1310_n400# VDD1v8 0.001032f
C2495 SAR_validpin_0/DFFR_5/a_n50_n400# SAR_validpin_0/DFFR_5/a_1460_n400# 0.006584f
C2496 SAR_validpin_0/DFFR_0/a_450_n400# SAR_validpin_0/DFFR_0/a_2600_n430# 0.002434f
C2497 VDD_5V SAR_validpin_0/DFFR_6/a_2550_n400# 5.26e-19
C2498 shift1v8to5_1/A strongarm_0/5v_pfet_1_1_0/D 4.89e-19
C2499 SAR_validpin_0/DFFR_7/a_1130_520# SAR_validpin_0/DFFRR_0/a_n560_n400# 3.29e-20
C2500 SAR_validpin_0/DFFR_7/a_350_n430# SAR_validpin_0/DFFRR_0/a_450_n400# 4.59e-20
C2501 SARclkgen_0/PHIA SAR_validpin_0/DFFR_8/a_90_n400# 0.069176f
C2502 SAR_validpin_0/DFFR_7/a_450_n400# SAR_validpin_0/DFFR_7/a_n420_n400# 0.252516f
C2503 SAR_validpin_0/DFFR_3/a_1130_520# SAR_validpin_0/DFFR_3/a_350_n430# 0.24593f
C2504 SAR_validpin_0/DFFRR_0/a_n420_720# RST_N 0.054432f
C2505 CLK5 SRLatch5V_0/R 2.56e-20
C2506 SAR_validpin_0/AND2_2/a_90_n200# SAR_validpin_0/OR2_0/B 0.0016f
C2507 SAR_validpin_0/OR2_2/A SAR_validpin_0/DFFRR_0/a_2600_n430# 0.009848f
C2508 SARclkgen_0/PHIB SAR_validpin_0/DFFR_7/a_1130_520# 0.115688f
C2509 shift1v8to5_4/5v_pfet_1_2_2/D SARclkgen_0/PHIA 0.071278f
C2510 SAR_validpin_0/DFFR_5/a_450_n400# SAR_validpin_0/DFFR_5/a_n50_n400# 0.819164f
C2511 CDAC_0/Vcm SARclkgen_0/PHIA 0.022343f
C2512 VDD1v8 CLK 2.471535f
C2513 SAR_validpin_0/DFFRR_1/a_1130_520# SAR_validpin_0/DFFRR_1/a_350_n430# 0.24593f
C2514 CDAC_0/b2 shift1v8to5_3/5v_pfet_1_2_0/D 0.405814f
C2515 VDD_5V SRLatch5V_0/R 3.454306f
C2516 VALID SAR_validpin_0/DFFR_8/a_n420_n400# 1.35e-19
C2517 strongarm_0/clk SARclkgen_0/AND2_1/a_n100_1100# 0.016204f
C2518 SAR_validpin_0/OR2_1/A shift1v8to5_0/A 0.039033f
C2519 SAR_validpin_0/DFFR_4/a_1310_n400# SAR_validpin_0/AND2_1/Y 0.005571f
C2520 SAR_validpin_0/OR2_2/A shift1v8to5_2/A 0.127343f
C2521 SAR_validpin_0/2_1_MUX_0/a_n1230_n310# SAR_validpin_0/OR2_0/B 0.450086f
C2522 SAR_validpin_0/DFFR_3/a_n50_n400# SAR_validpin_0/OR2_0/A 2.84e-20
C2523 SAR_validpin_0/DFFR_6/a_n50_n400# SAR_validpin_0/AND2_0/Y 1.86331f
C2524 SARclkgen_0/PHIA SAR_validpin_0/OR2_1/B 0.41866f
C2525 CLK_comp shift1v8to5_4/5v_pfet_1_2_0/D 0.459813f
C2526 ADC_OUT0 SAR_validpin_0/DFFR_3/a_2600_n430# 0.775495f
C2527 SAR_validpin_0/DFFR_3/a_450_n400# SAR_validpin_0/OR2_0/B 0.015747f
C2528 VDD1v8 SAR_validpin_0/OR2_1/a_100_310# 0.026043f
C2529 shift1v8to5_1/A SAR_validpin_0/DFFR_8/a_2600_n430# 0.002976f
C2530 VDD1v8 SAR_validpin_0/DFFR_4/a_1130_520# 0.557627f
C2531 SARclkgen_0/PHIA SAR_validpin_0/DFFRR_1/a_1130_520# 2.36e-19
C2532 SRLatch5V_0/NAND5v_0/5v_nfet_1_2_1/D SRLatch5V_0/R 0.563658f
C2533 VDD_5V SAR_validpin_0/DFFR_0/a_2550_n400# 4.83e-19
C2534 SAR_validpin_0/DFFR_4/a_n420_n400# SAR_validpin_0/DFFR_5/a_1130_520# 3.28e-20
C2535 SAR_validpin_0/DFFR_3/a_3210_n400# SAR_validpin_0/DFFR_3/a_2600_n430# 0.011304f
C2536 SAR_validpin_0/DFFR_0/a_2090_n400# SAR_validpin_0/DFFR_1/a_90_n400# 0.001682f
C2537 SAR_validpin_0/AND2_1/a_n100_1100# SAR_validpin_0/DFFR_1/a_2090_n400# 0.003951f
C2538 SAR_validpin_0/OR2_1/A SAR_validpin_0/DFFRR_0/a_1130_520# 0.010985f
C2539 SAR_validpin_0/DFFR_8/a_1130_520# SAR_validpin_0/DFFR_8/a_1460_n400# 0.002821f
C2540 SAR_validpin_0/DFFR_3/a_350_n430# SAR_validpin_0/AND2_1/Y 0.473948f
C2541 shift1v8to5_1/A SAR_validpin_0/DFFR_3/a_n50_n400# 0.005006f
C2542 SAR_validpin_0/DFFRR_0/a_350_n430# SAR_validpin_0/DFFRR_1/a_1130_520# 4.7e-20
C2543 SAR_validpin_0/DFFR_6/a_350_n430# SAR_validpin_0/DFFR_5/a_350_n430# 0.019353f
C2544 SAR_validpin_0/DFFR_0/a_n50_n400# SAR_validpin_0/DFFR_0/a_350_n430# 0.260805f
C2545 VALID SAR_validpin_0/DFFR_8/a_90_n400# 1.05e-19
C2546 SAR_validpin_0/OR2_0/B SAR_validpin_0/DFFRR_1/a_n240_n400# 0.004829f
C2547 SAR_validpin_0/DFFR_8/a_2550_720# VDD1v8 0.013971f
C2548 SAR_validpin_0/DFFR_5/a_n50_n400# SAR_validpin_0/AND2_1/Y 0.224575f
C2549 SAR_validpin_0/DFFR_5/a_1310_n400# SAR_validpin_0/DFFR_5/a_450_n400# 0.014507f
C2550 VDD1v8 shift1v8to5_1/5v_pfet_1_2_0/D 0.645801f
C2551 shift1v8to5_4/5v_pfet_1_2_2/D CLK5 0.010747f
C2552 Vin CDAC_0/SPDT_2/out 3.385798f
C2553 SAR_validpin_0/DFFR_2/a_1460_n400# VDD1v8 9.65e-19
C2554 shift1v8to5_0/A SAR_validpin_0/DFFRR_1/a_n560_n400# 6.14e-20
C2555 CLK5 CDAC_0/Vcm 3.513417f
C2556 SAR_validpin_0/OR2_0/B SAR_validpin_0/DFFRR_1/a_1310_n400# 2.46e-19
C2557 ADC_OUT1 ADC_OUT3 0.005731f
C2558 SAR_validpin_0/OR2_1/A SAR_validpin_0/DFFRR_1/a_n930_n400# 0.011639f
C2559 SAR_validpin_0/DFFR_4/a_2090_n400# ADC_OUT1 0.185504f
C2560 CLK5 SAR_validpin_0/OR2_1/B 4.18e-19
C2561 shift5to1v8_0/Y shift1v8to5_2/A 0.090905f
C2562 shift1v8to5_4/5v_pfet_1_2_2/D VDD_5V 1.834213f
C2563 shift1v8to5_0/5v_pfet_1_2_0/D CDAC_0/SPDT_1/out 0.009534f
C2564 SAR_validpin_0/DFFR_6/a_n50_n400# VALID 7e-19
C2565 VDD_5V CDAC_0/Vcm 0.664916f
C2566 SAR_validpin_0/DFFRR_1/a_350_n430# SAR_validpin_0/OR2_0/a_n80_n540# 0.006191f
C2567 VDD1v8 SAR_validpin_0/DFFR_8/a_350_n430# 1.225975f
C2568 SAR_validpin_0/DFFR_5/a_2090_n400# ADC_OUT2 0.185023f
C2569 SAR_validpin_0/DFFR_0/a_n420_n400# CDAC_0/SPDT_3/out 0.002073f
C2570 SRLatch5V_0/S SARclkgen_0/AND2_1/a_n100_1100# 0.001538f
C2571 SARclkgen_0/AND2_0/B NOT5V_0/Y 0.002604f
C2572 SAR_validpin_0/DFFR_6/a_n50_n400# VDD_5V 0.011158f
C2573 SARclkgen_0/PHIB SAR_validpin_0/DFFR_0/a_1460_n400# 0.011691f
C2574 shift1v8to5_0/5v_pfet_1_2_2/D CDAC_0/Vout 0.056781f
C2575 VALID SAR_validpin_0/OR2_1/B 0.002248f
C2576 SAR_validpin_0/DFFR_3/a_90_n400# SAR_validpin_0/DFFR_4/a_90_n400# 0.009533f
C2577 VDD_5V SAR_validpin_0/OR2_1/B 0.008926f
C2578 SAR_validpin_0/DFFR_3/a_n420_n400# SARclkgen_0/PHIA 6.88e-19
C2579 SAR_validpin_0/OR2_1/A SAR_validpin_0/DFFRR_0/a_n560_n400# 0.159279f
C2580 SAR_validpin_0/OR2_1/A SARclkgen_0/PHIB 0.647195f
C2581 SAR_validpin_0/DFFR_5/a_1310_n400# SAR_validpin_0/AND2_1/Y 0.005571f
C2582 SAR_validpin_0/AND2_0/Y SAR_validpin_0/DFFR_3/a_n420_n400# 0.509429f
C2583 SAR_validpin_0/DFFR_5/a_n420_n400# SAR_validpin_0/DFFR_4/a_n420_n400# 0.003453f
C2584 SAR_validpin_0/DFFS_0/a_n420_n400# SAR_validpin_0/DFFR_0/a_n420_n400# 8.97e-20
C2585 SAR_validpin_0/DFFR_0/a_n420_n400# shift1v8to5_3/A 7.61e-20
C2586 shift1v8to5_0/A SAR_validpin_0/DFFR_8/a_1460_n400# 0.001611f
C2587 SARclkgen_0/PHIA SAR_validpin_0/OR2_0/a_n80_n540# 0.005768f
C2588 SAR_validpin_0/DFFR_5/a_450_n400# SAR_validpin_0/DFFR_4/a_1130_520# 3.51e-19
C2589 SAR_validpin_0/OR2_0/A SAR_validpin_0/OR2_0/B 1.212874f
C2590 SAR_validpin_0/DFFR_0/a_2550_720# SAR_validpin_0/OR2_1/B 0.003486f
C2591 shift1v8to5_1/A SAR_validpin_0/DFFRR_0/a_1460_n400# 4.02e-19
C2592 SAR_validpin_0/DFFRR_1/a_n560_n400# SAR_validpin_0/DFFRR_1/a_n930_n400# 0.107114f
C2593 SAR_validpin_0/DFFR_7/a_2600_n430# SARclkgen_0/PHIA 0.133119f
C2594 SAR_validpin_0/DFFR_6/a_3210_n400# ADC_OUT3 0.007057f
C2595 SAR_validpin_0/DFFR_2/a_450_n400# SARclkgen_0/PHIB 0.79422f
C2596 SAR_validpin_0/DFFR_1/a_350_n430# SAR_validpin_0/OR2_1/B 0.213973f
C2597 VDD1v8 SRLatch5V_0/NAND5v_1/5v_nfet_1_2_1/D 0.028208f
C2598 shift5to1v8_0/Y SRLatch5V_0/R 2.61e-20
C2599 SAR_validpin_0/AND2_0/Y SAR_validpin_0/DFFR_7/a_2600_n430# 0.002481f
C2600 SAR_validpin_0/DFFRR_0/a_2550_n400# VDD1v8 4.37e-19
C2601 SAR_validpin_0/DFFS_0/a_2090_n400# NOT5V_0/Y 0.001131f
C2602 shift1v8to5_2/5v_pfet_1_2_2/D shift1v8to5_1/5v_pfet_1_2_2/D 0.016118f
C2603 shift1v8to5_1/A SARclkgen_0/AND2_0/a_n100_1100# 2.33e-19
C2604 SAR_validpin_0/DFFR_0/a_n50_n400# shift1v8to5_2/A 6.98e-21
C2605 shift1v8to5_1/A ADC_OUT1 0.154978f
C2606 shift1v8to5_1/A SAR_validpin_0/OR2_0/B 0.365893f
C2607 SAR_validpin_0/DFFR_7/D SAR_validpin_0/2_1_MUX_1/a_n1230_n310# 0.001216f
C2608 SAR_validpin_0/DFFR_6/a_450_n400# VDD1v8 0.507378f
C2609 SARclkgen_0/PHIA SRLatch5V_0/Q 0.001964f
C2610 SAR_validpin_0/DFFRR_1/a_n560_n400# SAR_validpin_0/DFFRR_0/a_n560_n400# 0.006664f
C2611 SARclkgen_0/PHIB SAR_validpin_0/DFFRR_1/a_n560_n400# 0.258145f
C2612 SAR_validpin_0/DFFR_6/a_n50_n400# SAR_validpin_0/OR2_2/A 0.137603f
C2613 ADC_OUT3 SAR_validpin_0/DFFR_6/a_2090_n400# 0.184665f
C2614 SAR_validpin_0/DFFR_1/a_450_n400# SAR_validpin_0/DFFR_1/a_90_n400# 0.143231f
C2615 SAR_validpin_0/OR2_2/A SAR_validpin_0/OR2_1/B 1.872975f
C2616 SAR_validpin_0/OR2_1/B SAR_validpin_0/2_1_MUX_2/a_n1230_n310# 0.004708f
C2617 SAR_validpin_0/DFFR_7/a_1130_520# SAR_validpin_0/DFFR_7/a_n420_n400# 0.088465f
C2618 SAR_validpin_0/DFFR_4/a_1130_520# SAR_validpin_0/AND2_1/Y 0.115688f
C2619 SAR_validpin_0/DFFR_4/a_n420_n400# SAR_validpin_0/DFFR_4/a_90_n400# 0.438846f
C2620 SAR_validpin_0/OR2_2/B SAR_validpin_0/DFFR_0/a_n420_n400# 0.190053f
C2621 CDAC_0/b1 shift1v8to5_2/A 0.013901f
C2622 SAR_validpin_0/DFFR_8/a_1130_520# SAR_validpin_0/DFFS_0/a_450_n400# 4.89e-19
C2623 SAR_validpin_0/OR2_0/a_100_310# SARclkgen_0/PHIA 0.00235f
C2624 SARclkgen_0/PHIA SAR_validpin_0/DFFR_0/a_2600_n430# 0.247194f
C2625 CLK5 CDAC_0/b0 6.535986f
C2626 SAR_validpin_0/DFFRR_0/a_n930_n400# SAR_validpin_0/OR2_2/B 2.03e-19
C2627 SARclkgen_0/AND2_1/B strongarm_0/clk 0.014795f
C2628 SAR_validpin_0/DFFR_7/a_2600_n430# VALID 0.001182f
C2629 SAR_validpin_0/DFFR_6/a_1130_520# shift1v8to5_1/A 3.57e-19
C2630 SAR_validpin_0/DFFS_0/a_450_n400# SAR_validpin_0/DFFS_0/a_600_n400# 0.60828f
C2631 SAR_validpin_0/DFFRR_1/D SAR_validpin_0/OR2_0/B 0.514784f
C2632 CLK_comp SARclkgen_0/AND2_0/A 0.029221f
C2633 VDD_5V SAR_validpin_0/DFFR_7/a_2600_n430# 0.015911f
C2634 VDD_5V CDAC_0/b0 1.789019f
C2635 Vin CDAC_0/b2 1.439279f
C2636 shift1v8to5_0/A SAR_validpin_0/DFFR_0/a_2090_n400# 2.31e-19
C2637 SARclkgen_0/PHIB SAR_validpin_0/DFFR_8/a_1460_n400# 0.009764f
C2638 RST_N SAR_validpin_0/DFFR_8/a_2600_n430# 0.668665f
C2639 SAR_validpin_0/DFFR_7/a_n50_n400# SAR_validpin_0/DFFRR_0/a_1130_520# 3.29e-20
C2640 SAR_validpin_0/DFFR_3/a_450_n400# SAR_validpin_0/DFFR_3/a_2090_n400# 0.28571f
C2641 RST_N SAR_validpin_0/DFFR_3/a_n50_n400# 0.177913f
C2642 shift5to1v8_0/Y SAR_validpin_0/OR2_1/B 0.139135f
C2643 SAR_validpin_0/DFFS_0/a_1310_n400# CDAC_0/SPDT_3/out 3.5e-19
C2644 SAR_validpin_0/DFFS_0/a_1130_520# SAR_validpin_0/DFFR_8/a_n50_n400# 4.93e-20
C2645 SAR_validpin_0/DFFR_1/a_n420_n400# shift1v8to5_3/A 3.67e-20
C2646 SAR_validpin_0/DFFR_1/a_350_n430# SAR_validpin_0/OR2_0/a_n80_n540# 0.001077f
C2647 SAR_validpin_0/DFFR_6/a_450_n400# SAR_validpin_0/DFFR_5/a_450_n400# 0.018533f
C2648 SAR_validpin_0/DFFRR_0/a_n240_n400# SAR_validpin_0/DFFRR_0/a_n340_n430# 0.004376f
C2649 VDD_5V SRLatch5V_0/Q 2.600245f
C2650 shift1v8to5_1/A SAR_validpin_0/DFFR_6/a_2090_n400# 7.75e-19
C2651 SAR_validpin_0/DFFR_8/a_450_n400# shift1v8to5_1/A 0.064337f
C2652 SAR_validpin_0/DFFR_6/a_n420_n400# SAR_validpin_0/DFFR_5/a_1130_520# 3.28e-20
C2653 SAR_validpin_0/DFFS_0/a_n420_n400# VDD1v8 0.607757f
C2654 SAR_validpin_0/DFFS_0/a_n50_n400# SAR_validpin_0/DFFS_0/a_600_n400# 0.06634f
C2655 SARclkgen_0/PHIB SAR_validpin_0/DFFR_7/a_2090_n400# 2.44e-19
C2656 VDD_5V SAR_validpin_0/DFFR_0/a_2600_n430# 0.014951f
C2657 shift5to1v8_0/5v_pfet_1_2_1/G shift1v8to5_3/5v_pfet_1_2_2/D 8.71e-19
C2658 SAR_validpin_0/DFFS_0/a_n420_n400# SAR_validpin_0/DFFS_0/a_1310_n400# 0.002942f
C2659 VDD1v8 SAR_validpin_0/DFFR_6/a_2600_n430# 0.951858f
C2660 VDD1v8 SAR_validpin_0/OR2_1/a_n80_n540# 0.456586f
C2661 VDD1v8 shift1v8to5_3/A 1.632455f
C2662 SRLatch5V_0/NAND5v_0/5v_nfet_1_2_1/D SRLatch5V_0/Q 0.270595f
C2663 SAR_validpin_0/DFFR_4/a_2090_n400# SAR_validpin_0/DFFR_3/a_2090_n400# 0.01523f
C2664 SAR_validpin_0/DFFR_7/a_2550_720# SAR_validpin_0/DFFR_7/a_2090_n400# 0.011347f
C2665 SAR_validpin_0/DFFR_0/a_350_n430# SAR_validpin_0/DFFR_0/a_n420_n400# 0.316282f
C2666 SAR_validpin_0/DFFRR_1/a_2600_n430# SAR_validpin_0/DFFR_4/a_450_n400# 9.02e-21
C2667 shift1v8to5_0/5v_pfet_1_2_0/D VDD1v8 0.609391f
C2668 SAR_validpin_0/DFFS_0/a_2090_n400# CDAC_0/Vout 0.00947f
C2669 SRLatch5V_0/S SARclkgen_0/AND2_1/B 1.1e-19
C2670 SAR_validpin_0/AND2_1/a_n100_1100# SAR_validpin_0/OR2_0/A 0.00781f
C2671 NOT5V_0/Y SAR_validpin_0/DFFR_0/a_1460_n400# 2.24e-20
C2672 shift1v8to5_2/5v_pfet_1_2_2/D SRLatch5V_0/NQ 1.22e-19
C2673 CDAC_0/SPDT_2/out CDAC_0/SPDT_3/out 0.117397f
C2674 SAR_validpin_0/DFFR_0/a_1310_n400# SAR_validpin_0/OR2_2/B 1.93e-19
C2675 SAR_validpin_0/DFFR_7/a_n50_n400# SAR_validpin_0/DFFRR_0/a_n560_n400# 0.010583f
C2676 SAR_validpin_0/DFFR_7/a_2600_n430# SAR_validpin_0/OR2_2/A 0.833696f
C2677 shift1v8to5_2/5v_pfet_1_2_2/D CDAC_0/Vout 1.9e-19
C2678 shift1v8to5_1/A SAR_validpin_0/DFFR_7/a_450_n400# 4.67e-19
C2679 SARclkgen_0/PHIB SAR_validpin_0/DFFR_7/a_n50_n400# 0.227962f
C2680 SAR_validpin_0/DFFR_6/a_450_n400# SAR_validpin_0/AND2_1/Y 0.794512f
C2681 SAR_validpin_0/AND2_0/Y SAR_validpin_0/DFFR_4/a_n50_n400# 1.934101f
C2682 SAR_validpin_0/DFFRR_0/a_n240_n400# shift1v8to5_1/A 0.001362f
C2683 SAR_validpin_0/DFFR_2/a_2600_n430# SAR_validpin_0/DFFR_3/a_2090_n400# 4e-19
C2684 SAR_validpin_0/DFFR_2/a_2090_n400# SAR_validpin_0/DFFR_3/a_2600_n430# 4e-19
C2685 SAR_validpin_0/OR2_1/A SAR_validpin_0/DFFR_7/a_n420_n400# 0.003565f
C2686 SAR_validpin_0/DFFR_7/a_1310_n400# SAR_validpin_0/DFFR_7/a_450_n400# 0.014507f
C2687 SAR_validpin_0/DFFR_0/a_n50_n400# SAR_validpin_0/OR2_1/B 0.026629f
C2688 SAR_validpin_0/DFFR_1/a_350_n430# SAR_validpin_0/DFFR_0/a_2600_n430# 3.16e-20
C2689 SAR_validpin_0/DFFR_2/a_450_n400# SAR_validpin_0/DFFR_1/a_2600_n430# 9.02e-21
C2690 shift1v8to5_1/A SAR_validpin_0/AND2_1/a_n100_1100# 0.385615f
C2691 SARclkgen_0/PHIB SAR_validpin_0/DFFR_0/a_2090_n400# 0.177322f
C2692 SAR_validpin_0/DFFS_0/a_n420_n400# CDAC_0/SPDT_2/out 0.002073f
C2693 CDAC_0/SPDT_4/out Vin 3.691303f
C2694 SAR_validpin_0/DFFRR_1/a_2600_n430# SAR_validpin_0/DFFRR_0/a_2600_n430# 0.010329f
C2695 VDD1v8 SAR_validpin_0/OR2_2/B 2.519282f
C2696 CDAC_0/Vcm CDAC_0/b1 0.209539f
C2697 shift1v8to5_0/5v_pfet_1_2_0/D CDAC_0/SPDT_2/out 0.006489f
C2698 SAR_validpin_0/DFFS_0/a_2090_n400# SAR_validpin_0/DFFR_0/a_90_n400# 0.001685f
C2699 RST_N SARclkgen_0/AND2_0/a_n100_1100# 3.6e-19
C2700 shift5to1v8_0/Y SAR_validpin_0/OR2_0/a_n80_n540# 0.046427f
C2701 SAR_validpin_0/DFFR_6/a_n420_n400# SAR_validpin_0/DFFR_5/a_n420_n400# 0.010516f
C2702 RST_N SAR_validpin_0/OR2_0/B 0.440944f
C2703 CDAC_0/Vcm SAR_validpin_0/DFFR_2/a_90_n400# 0.002041f
C2704 SAR_validpin_0/DFFR_6/a_2550_720# SAR_validpin_0/DFFR_6/a_2090_n400# 0.011347f
C2705 RST_N ADC_OUT1 0.409191f
C2706 shift1v8to5_0/A SAR_validpin_0/DFFR_1/a_450_n400# 0.001203f
C2707 shift1v8to5_1/A SAR_validpin_0/DFFR_3/a_2090_n400# 0.003063f
C2708 VDD1v8 strongarm_0/5v_nfet_1_1_3/S 0.045644f
C2709 SRLatch5V_0/NAND5v_1/5v_nfet_1_2_1/D CDAC_0/b2 0.003918f
C2710 SARclkgen_0/PHIB SAR_validpin_0/DFFS_0/a_450_n400# 0.262395f
C2711 SAR_validpin_0/DFFRR_0/a_n930_n400# SAR_validpin_0/DFFRR_0/a_2600_n430# 4.26e-20
C2712 CDAC_0/Vcm SAR_validpin_0/DFFR_2/a_350_n430# 0.005366f
C2713 VDD_5V SAR_validpin_0/DFFR_4/a_n50_n400# 0.004559f
C2714 shift1v8to5_2/A SAR_validpin_0/DFFR_0/a_n420_n400# 1.77e-20
C2715 VDD1v8 SAR_validpin_0/DFFR_3/a_2600_n430# 0.971182f
C2716 strongarm_0/clk VDD1v8 1.725415f
C2717 SAR_validpin_0/DFFR_2/a_450_n400# SAR_validpin_0/DFFR_1/a_2090_n400# 2.95e-20
C2718 SAR_validpin_0/DFFRR_1/a_2600_n430# SAR_validpin_0/DFFR_4/a_350_n430# 3.16e-20
C2719 SAR_validpin_0/DFFR_0/a_1310_n400# SAR_validpin_0/DFFR_0/a_350_n430# 0.006999f
C2720 VDD_5V SAR_validpin_0/DFFR_3/a_2550_720# 8.67e-19
C2721 SAR_validpin_0/OR2_2/B SAR_validpin_0/DFFR_7/a_90_n400# 7.27e-20
C2722 SAR_validpin_0/AND2_1/a_90_n200# SAR_validpin_0/AND2_1/a_n100_1100# 0.011051f
C2723 shift1v8to5_1/A SARclkgen_0/AND2_0/B 1.42e-19
C2724 SAR_validpin_0/DFFR_6/a_1130_520# RST_N 0.435474f
C2725 shift1v8to5_5/5v_pfet_1_2_0/D CLK 0.459813f
C2726 SAR_validpin_0/DFFR_4/a_2090_n400# SAR_validpin_0/DFFR_5/a_2090_n400# 0.008351f
C2727 SAR_validpin_0/DFFR_5/a_2090_n400# ADC_OUT3 3.07e-20
C2728 RST_N SAR_validpin_0/DFFR_6/a_3210_n400# 0.004852f
C2729 SARclkgen_0/AND2_1/B SRLatch5V_0/R 7.76e-19
C2730 SAR_validpin_0/DFFS_0/a_n50_n400# SARclkgen_0/PHIB 0.213941f
C2731 SAR_validpin_0/AND2_1/Y SAR_validpin_0/DFFR_6/a_2600_n430# 4.47e-19
C2732 SAR_validpin_0/DFFR_8/a_n50_n400# SARclkgen_0/PHIA 1.890293f
C2733 VDD1v8 SAR_validpin_0/DFFR_0/a_350_n430# 1.230353f
C2734 SAR_validpin_0/DFFR_0/a_1460_n400# CDAC_0/Vout 7.38e-19
C2735 SAR_validpin_0/DFFRR_0/a_n420_720# SAR_validpin_0/DFFRR_0/a_n240_n400# 0.011322f
C2736 RST_N SAR_validpin_0/DFFR_6/a_2090_n400# 0.470411f
C2737 SAR_validpin_0/DFFR_5/a_n420_n400# SAR_validpin_0/DFFR_5/a_90_n400# 0.438846f
C2738 SAR_validpin_0/DFFR_4/a_450_n400# VDD1v8 0.52135f
C2739 RST_N SAR_validpin_0/DFFR_7/a_2550_n400# 7.85e-19
C2740 SAR_validpin_0/DFFR_8/a_450_n400# RST_N 0.29523f
C2741 SAR_validpin_0/AND2_0/Y SAR_validpin_0/DFFR_5/a_1130_520# 0.002119f
C2742 SARclkgen_0/PHIA SAR_validpin_0/DFFS_0/a_90_n400# 0.099546f
C2743 SARclkgen_0/PHIB SAR_validpin_0/DFFR_1/a_450_n400# 0.972024f
C2744 SRLatch5V_0/S VDD1v8 0.450641f
C2745 SRLatch5V_0/Q SARclkgen_0/AND2_1/a_n100_1100# 9.14e-19
C2746 SARclkgen_0/PHIA CLK_comp 0.381012f
C2747 SAR_validpin_0/DFFR_7/a_2090_n400# SAR_validpin_0/DFFR_7/a_n420_n400# 1.11e-20
C2748 shift1v8to5_1/A SAR_validpin_0/DFFS_0/a_2090_n400# 0.136341f
C2749 CDAC_0/b1 CDAC_0/b0 7.888639f
C2750 SAR_validpin_0/DFFR_3/a_n420_n400# SAR_validpin_0/DFFR_2/a_350_n430# 1.21e-19
C2751 shift1v8to5_2/5v_pfet_1_2_2/D shift1v8to5_1/A 5.32e-19
C2752 SAR_validpin_0/DFFR_2/a_n50_n400# SAR_validpin_0/DFFR_2/a_n420_n400# 0.115912f
C2753 VDD1v8 SAR_validpin_0/DFFS_0/a_2550_720# 0.013128f
C2754 CDAC_0/b2 shift1v8to5_3/A 0.281972f
C2755 SAR_validpin_0/OR2_1/A SAR_validpin_0/2_1_MUX_0/a_n1230_n310# 0.123556f
C2756 RST_N SAR_validpin_0/DFFR_7/a_450_n400# 0.302686f
C2757 SAR_validpin_0/DFFR_0/a_n50_n400# SAR_validpin_0/DFFR_0/a_2600_n430# 0.101509f
C2758 SAR_validpin_0/DFFR_7/a_n50_n400# SAR_validpin_0/DFFR_7/a_n420_n400# 0.116062f
C2759 SAR_validpin_0/DFFR_5/a_2090_n400# shift1v8to5_1/A 2.59e-19
C2760 SAR_validpin_0/DFFR_7/a_350_n430# SAR_validpin_0/DFFRR_0/a_n560_n400# 8.42e-20
C2761 SARclkgen_0/PHIA SAR_validpin_0/DFFR_8/a_2090_n400# 0.467713f
C2762 VDD1v8 SAR_validpin_0/DFFRR_0/a_2600_n430# 1.010802f
C2763 shift1v8to5_1/A SAR_validpin_0/DFFR_7/a_1130_520# 3.57e-19
C2764 SAR_validpin_0/DFFR_8/a_n50_n400# VALID 0.02239f
C2765 SARclkgen_0/PHIB SAR_validpin_0/DFFR_7/a_350_n430# 0.474818f
C2766 SAR_validpin_0/AND2_2/a_n100_1100# SAR_validpin_0/DFFRR_1/a_1130_520# 9.83e-20
C2767 CLK5 SAR_validpin_0/DFFS_0/a_90_n400# 1.08e-20
C2768 RST_N SAR_validpin_0/AND2_1/a_n100_1100# 0.003631f
C2769 SAR_validpin_0/DFFR_5/a_90_n400# SAR_validpin_0/DFFR_4/a_90_n400# 0.002406f
C2770 SAR_validpin_0/DFFR_7/a_1310_n400# SAR_validpin_0/DFFR_7/a_1130_520# 0.002821f
C2771 SAR_validpin_0/DFFR_5/a_2600_n430# VDD1v8 0.971182f
C2772 SAR_validpin_0/DFFRR_0/a_3210_n400# SAR_validpin_0/DFFRR_0/a_2600_n430# 0.011304f
C2773 NOT5V_0/Y SAR_validpin_0/DFFR_0/a_2090_n400# 2.98e-19
C2774 CLK5 CLK_comp 0.079851f
C2775 SAR_validpin_0/DFFR_7/D SAR_validpin_0/DFFRR_0/D 7.45e-20
C2776 SAR_validpin_0/DFFR_5/a_n420_n400# SARclkgen_0/PHIA 1.79e-19
C2777 VDD1v8 shift1v8to5_2/A 1.401993f
C2778 SAR_validpin_0/DFFS_0/a_3210_n400# CDAC_0/SPDT_3/out 2.69e-19
C2779 VALID SAR_validpin_0/DFFS_0/a_90_n400# 0.001571f
C2780 SAR_validpin_0/DFFR_4/a_450_n400# SAR_validpin_0/DFFR_3/a_1130_520# 9.74e-20
C2781 SAR_validpin_0/AND2_0/Y SAR_validpin_0/DFFR_5/a_n420_n400# 0.154087f
C2782 SAR_validpin_0/AND2_1/Y SAR_validpin_0/DFFR_3/a_2600_n430# 4.47e-19
C2783 VDD_5V SAR_validpin_0/DFFS_0/a_90_n400# 0.002389f
C2784 SAR_validpin_0/DFFR_2/a_450_n400# SAR_validpin_0/DFFR_3/a_450_n400# 0.011404f
C2785 SAR_validpin_0/DFFS_0/a_350_n430# SAR_validpin_0/DFFR_8/a_350_n430# 1.78e-19
C2786 SAR_validpin_0/DFFRR_1/a_n340_n430# SAR_validpin_0/DFFRR_1/a_350_n430# 0.027962f
C2787 SAR_validpin_0/OR2_1/B SAR_validpin_0/DFFR_0/a_n420_n400# 8.58e-19
C2788 SAR_validpin_0/DFFR_4/a_450_n400# SAR_validpin_0/DFFR_5/a_450_n400# 0.010201f
C2789 RST_N SAR_validpin_0/DFFR_4/a_3210_n400# 0.004852f
C2790 SAR_validpin_0/OR2_0/B SAR_validpin_0/DFFR_1/a_3210_n400# 0.006503f
C2791 SARclkgen_0/PHIA SAR_validpin_0/DFFRR_0/a_1310_n400# 0.003674f
C2792 VDD_5V CLK_comp 0.291485f
C2793 SAR_validpin_0/DFFR_3/a_n50_n400# SAR_validpin_0/OR2_0/B 0.033398f
C2794 SAR_validpin_0/2_1_MUX_0/a_n1230_n310# SAR_validpin_0/DFFRR_1/a_n560_n400# 3.54e-19
C2795 VDD1v8 SAR_validpin_0/OR2_2/a_100_310# 0.026043f
C2796 RST_N SAR_validpin_0/DFFR_3/a_2090_n400# 0.473804f
C2797 SAR_validpin_0/DFFRR_0/a_n930_n400# SAR_validpin_0/OR2_1/B 0.002563f
C2798 VDD1v8 SAR_validpin_0/DFFR_4/a_350_n430# 1.262604f
C2799 CDAC_0/SPDT_4/out CDAC_0/SPDT_3/out 0.117396f
C2800 SAR_validpin_0/DFFR_4/a_n420_n400# SAR_validpin_0/DFFR_5/a_350_n430# 1.21e-19
C2801 SAR_validpin_0/DFFS_0/a_n420_n400# SAR_validpin_0/DFFS_0/a_3210_n400# 1.79e-19
C2802 SAR_validpin_0/DFFRR_0/a_350_n430# SAR_validpin_0/DFFRR_0/a_1310_n400# 0.006999f
C2803 SAR_validpin_0/DFFS_0/a_450_n400# NOT5V_0/Y 8.66e-19
C2804 SAR_validpin_0/OR2_1/A SAR_validpin_0/DFFRR_0/a_n340_n430# 0.040786f
C2805 SARclkgen_0/PHIA SAR_validpin_0/DFFRR_1/a_n340_n430# 0.126994f
C2806 SAR_validpin_0/DFFRR_0/a_n930_n400# SAR_validpin_0/DFFRR_1/a_1130_520# 3.28e-20
C2807 VALID SAR_validpin_0/DFFR_8/a_2090_n400# 0.195449f
C2808 SAR_validpin_0/DFFR_5/a_1310_n400# SAR_validpin_0/DFFR_5/a_n50_n400# 0.006175f
C2809 SAR_validpin_0/DFFR_5/a_2090_n400# SAR_validpin_0/DFFR_5/a_2550_n400# 0.006257f
C2810 strongarm_0/5v_nfet_1_1_3/S CDAC_0/b2 0.003902f
C2811 shift5to1v8_0/5v_pfet_1_2_1/G SARclkgen_0/PHIB 0.034272f
C2812 SAR_validpin_0/DFFR_5/a_450_n400# SAR_validpin_0/DFFRR_0/a_2600_n430# 9.02e-21
C2813 SAR_validpin_0/DFFRR_1/a_n560_n400# SAR_validpin_0/DFFRR_1/a_n240_n400# 0.010714f
C2814 SAR_validpin_0/DFFR_1/a_1460_n400# SAR_validpin_0/DFFR_1/a_450_n400# 0.010382f
C2815 VDD1v8 SRLatch5V_0/R 0.490847f
C2816 SAR_validpin_0/DFFR_4/a_450_n400# SAR_validpin_0/AND2_1/Y 0.793639f
C2817 SAR_validpin_0/DFFRR_1/a_1310_n400# SAR_validpin_0/DFFRR_1/a_n560_n400# 0.006054f
C2818 RST_N SARclkgen_0/AND2_0/B 1.96e-19
C2819 strongarm_0/5v_pfet_1_1_3/D VDD_5V 0.434136f
C2820 SAR_validpin_0/AND2_2/a_n100_1100# SAR_validpin_0/OR2_0/a_n80_n540# 0.005049f
C2821 SAR_validpin_0/OR2_1/A SAR_validpin_0/OR2_0/A 0.088363f
C2822 SAR_validpin_0/AND2_0/Y SAR_validpin_0/DFFR_4/a_90_n400# 0.102842f
C2823 strongarm_0/clk CDAC_0/b2 0.003545f
C2824 VDD1v8 SAR_validpin_0/DFFR_8/a_n420_n400# 0.485854f
C2825 SAR_validpin_0/DFFR_4/a_1310_n400# SAR_validpin_0/DFFR_4/a_1130_520# 0.002821f
C2826 SARclkgen_0/PHIA SAR_validpin_0/DFFRR_0/a_450_n400# 0.346812f
C2827 CDAC_0/SPDT_1/out CDAC_0/b0 0.090423f
C2828 SARclkgen_0/PHIA SAR_validpin_0/2_1_MUX_1/a_n1230_n310# 0.003875f
C2829 SAR_validpin_0/DFFR_5/a_2600_n430# SAR_validpin_0/DFFR_5/a_450_n400# 0.002434f
C2830 SAR_validpin_0/DFFR_2/a_450_n400# SAR_validpin_0/DFFR_2/a_2600_n430# 0.002434f
C2831 SAR_validpin_0/DFFRR_1/a_n420_720# SAR_validpin_0/OR2_0/a_n80_n540# 0.00261f
C2832 SAR_validpin_0/OR2_1/B SAR_validpin_0/DFFR_1/a_n50_n400# 0.141629f
C2833 SAR_validpin_0/DFFRR_0/a_350_n430# SAR_validpin_0/DFFRR_0/a_450_n400# 0.980343f
C2834 SAR_validpin_0/DFFS_0/a_n50_n400# NOT5V_0/Y 1.62e-19
C2835 ADC_OUT0 SAR_validpin_0/DFFR_3/a_2550_720# 1.75e-19
C2836 SAR_validpin_0/DFFRR_0/a_350_n430# SAR_validpin_0/2_1_MUX_1/a_n1230_n310# 8.48e-20
C2837 SAR_validpin_0/DFFS_0/a_3210_n400# SAR_validpin_0/OR2_2/B 0.006653f
C2838 SAR_validpin_0/DFFR_2/a_2550_n400# RST_N 9.24e-19
C2839 SAR_validpin_0/OR2_1/A shift1v8to5_1/A 0.106405f
C2840 SAR_validpin_0/DFFR_8/a_450_n400# SAR_validpin_0/DFFR_8/a_2600_n430# 0.002434f
C2841 SAR_validpin_0/DFFR_1/a_450_n400# SAR_validpin_0/DFFR_1/a_2600_n430# 0.002434f
C2842 CDAC_0/SPDT_0/out CDAC_0/b3 0.963357f
C2843 SAR_validpin_0/DFFR_7/a_1310_n400# SAR_validpin_0/OR2_1/A 8.06e-19
C2844 SAR_validpin_0/AND2_1/Y SAR_validpin_0/DFFRR_0/a_2600_n430# 0.022105f
C2845 SAR_validpin_0/DFFR_6/a_n420_n400# SAR_validpin_0/DFFR_6/a_90_n400# 0.438846f
C2846 SAR_validpin_0/DFFR_0/a_1310_n400# SAR_validpin_0/OR2_1/B 1.89e-19
C2847 VDD1v8 SAR_validpin_0/DFFR_8/a_90_n400# 0.418683f
C2848 SAR_validpin_0/DFFR_4/a_n420_n400# SAR_validpin_0/DFFR_4/a_1460_n400# 0.001621f
C2849 SAR_validpin_0/OR2_0/A SAR_validpin_0/DFFRR_1/a_n560_n400# 0.211529f
C2850 NOT5V_0/Y SAR_validpin_0/DFFR_1/a_450_n400# 2.47e-20
C2851 SAR_validpin_0/DFFR_2/a_450_n400# shift1v8to5_1/A 0.055244f
C2852 RST_N SAR_validpin_0/DFFS_0/a_2090_n400# 0.584614f
C2853 SAR_validpin_0/DFFR_2/a_n50_n400# SARclkgen_0/PHIB 0.221507f
C2854 SAR_validpin_0/DFFR_1/a_n420_n400# SAR_validpin_0/OR2_1/B 0.102796f
C2855 CDAC_0/Vout SAR_validpin_0/DFFR_0/a_2090_n400# 0.011111f
C2856 shift1v8to5_4/5v_pfet_1_2_2/D VDD1v8 0.840751f
C2857 SAR_validpin_0/DFFR_7/D SAR_validpin_0/DFFRR_0/a_n560_n400# 4.09e-20
C2858 SAR_validpin_0/DFFR_5/a_2600_n430# SAR_validpin_0/AND2_1/Y 4.47e-19
C2859 CDAC_0/Vcm VDD1v8 0.015155f
C2860 SAR_validpin_0/DFFR_3/D SAR_validpin_0/DFFRR_1/a_1130_520# 7.92e-19
C2861 SAR_validpin_0/DFFR_7/D SARclkgen_0/PHIB 0.446501f
C2862 RST_N SAR_validpin_0/DFFRR_0/a_2090_n400# 0.471605f
C2863 SAR_validpin_0/DFFR_4/a_2600_n430# SAR_validpin_0/DFFR_3/a_2600_n430# 0.01493f
C2864 SAR_validpin_0/DFFR_6/a_n50_n400# VDD1v8 0.503598f
C2865 SRLatch5V_0/S CDAC_0/b2 0.008828f
C2866 shift1v8to5_1/A SAR_validpin_0/DFFRR_1/a_n560_n400# 0.174933f
C2867 SARclkgen_0/PHIB shift1v8to5_4/5v_pfet_1_2_0/D 0.004098f
C2868 VALID SAR_validpin_0/2_1_MUX_1/a_n1230_n310# 0.001111f
C2869 SAR_validpin_0/DFFRR_1/D SAR_validpin_0/OR2_1/A 0.245351f
C2870 SAR_validpin_0/DFFR_5/a_2090_n400# RST_N 0.472287f
C2871 SARclkgen_0/PHIA SAR_validpin_0/DFFRR_1/a_3210_n400# 4.1e-19
C2872 VDD1v8 SAR_validpin_0/DFFRR_0/a_2550_720# 0.014691f
C2873 VDD1v8 SAR_validpin_0/OR2_1/B 2.314077f
C2874 SAR_validpin_0/DFFS_0/a_350_n430# CDAC_0/SPDT_3/out 4.73e-19
C2875 VDD_5V SAR_validpin_0/2_1_MUX_1/a_n1230_n310# 1.75e-19
C2876 SAR_validpin_0/AND2_0/Y SAR_validpin_0/DFFRR_1/a_3210_n400# 0.001496f
C2877 RST_N SAR_validpin_0/DFFR_7/a_1130_520# 0.435474f
C2878 SAR_validpin_0/AND2_0/Y SAR_validpin_0/DFFR_3/a_2550_n400# 0.001071f
C2879 SAR_validpin_0/DFFR_1/a_450_n400# SAR_validpin_0/DFFR_1/a_2090_n400# 0.28571f
C2880 SAR_validpin_0/OR2_2/A SAR_validpin_0/DFFRR_0/a_1310_n400# 8.42e-19
C2881 SAR_validpin_0/DFFR_7/a_350_n430# SAR_validpin_0/DFFR_7/a_n420_n400# 0.316282f
C2882 SAR_validpin_0/DFFR_4/a_350_n430# SAR_validpin_0/AND2_1/Y 0.470366f
C2883 SAR_validpin_0/DFFS_0/a_450_n400# CDAC_0/Vout 0.018766f
C2884 VDD1v8 SAR_validpin_0/DFFRR_1/a_1130_520# 0.551335f
C2885 SAR_validpin_0/DFFRR_1/a_450_n400# SAR_validpin_0/DFFRR_1/a_350_n430# 0.980343f
C2886 SAR_validpin_0/DFFR_0/a_n420_n400# SAR_validpin_0/DFFR_0/a_2600_n430# 4.26e-20
C2887 SAR_validpin_0/OR2_2/A SAR_validpin_0/DFFRR_1/a_n340_n430# 2.5e-20
C2888 SAR_validpin_0/DFFS_0/a_350_n430# SAR_validpin_0/DFFS_0/a_n420_n400# 0.238641f
C2889 SAR_validpin_0/DFFR_4/a_450_n400# SAR_validpin_0/DFFRR_1/a_2090_n400# 2.95e-20
C2890 SAR_validpin_0/DFFR_6/a_350_n430# shift1v8to5_1/A 6.3e-19
C2891 SAR_validpin_0/DFFR_3/a_n420_n400# SAR_validpin_0/DFFR_3/D 0.055486f
C2892 shift1v8to5_2/A CDAC_0/b2 0.297054f
C2893 shift1v8to5_1/A SAR_validpin_0/DFFR_8/a_1460_n400# 1.52e-19
C2894 SAR_validpin_0/DFFR_6/a_90_n400# SAR_validpin_0/DFFR_5/a_90_n400# 0.009533f
C2895 SAR_validpin_0/DFFR_4/a_2600_n430# SAR_validpin_0/DFFR_4/a_450_n400# 0.002434f
C2896 SARclkgen_0/PHIA SAR_validpin_0/DFFRR_1/a_450_n400# 0.339735f
C2897 SAR_validpin_0/DFFRR_1/D SAR_validpin_0/DFFRR_1/a_n560_n400# 0.103287f
C2898 CDAC_0/SPDT_4/out SAR_validpin_0/DFFR_0/a_350_n430# 0.00171f
C2899 SAR_validpin_0/DFFR_0/a_450_n400# SAR_validpin_0/DFFS_0/a_600_n400# 1.94e-20
C2900 SAR_validpin_0/DFFR_3/a_n50_n400# SAR_validpin_0/DFFR_3/a_2090_n400# 0.596801f
C2901 CLK_comp SARclkgen_0/AND2_1/a_n100_1100# 0.015996f
C2902 SAR_validpin_0/DFFS_0/a_450_n400# SAR_validpin_0/DFFR_0/a_90_n400# 1.7e-19
C2903 SAR_validpin_0/DFFR_7/a_n50_n400# SAR_validpin_0/DFFRR_0/a_n340_n430# 3.75e-21
C2904 SAR_validpin_0/AND2_0/Y SAR_validpin_0/DFFR_5/a_3210_n400# 4.1e-19
C2905 shift1v8to5_3/A shift1v8to5_3/5v_pfet_1_2_0/D 0.460277f
C2906 SAR_validpin_0/DFFR_3/D SAR_validpin_0/OR2_0/a_n80_n540# 5.71e-19
C2907 SAR_validpin_0/DFFRR_0/a_n420_720# SAR_validpin_0/OR2_1/A 0.052319f
C2908 SAR_validpin_0/OR2_2/A SAR_validpin_0/DFFRR_0/a_450_n400# 0.009683f
C2909 SAR_validpin_0/DFFS_0/a_n50_n400# CDAC_0/Vout 0.010842f
C2910 SAR_validpin_0/DFFR_3/a_2550_n400# VDD_5V 5.26e-19
C2911 SAR_validpin_0/DFFS_0/a_1130_520# SAR_validpin_0/DFFR_8/a_1130_520# 0.002837f
C2912 SAR_validpin_0/DFFR_6/a_n50_n400# SAR_validpin_0/DFFR_5/a_450_n400# 6.99e-20
C2913 SAR_validpin_0/DFFR_6/a_450_n400# SAR_validpin_0/DFFR_5/a_n50_n400# 6.99e-20
C2914 shift1v8to5_0/5v_pfet_1_2_0/D shift1v8to5_3/5v_pfet_1_2_0/D 0.002343f
C2915 SAR_validpin_0/DFFR_3/a_90_n400# SAR_validpin_0/AND2_0/a_n100_1100# 8.45e-19
C2916 SAR_validpin_0/OR2_2/A SAR_validpin_0/2_1_MUX_1/a_n1230_n310# 0.100698f
C2917 SAR_validpin_0/DFFR_3/a_n420_n400# VDD1v8 0.530708f
C2918 SAR_validpin_0/2_1_MUX_2/a_n1230_n310# SAR_validpin_0/2_1_MUX_1/a_n1230_n310# 0.004163f
C2919 shift1v8to5_1/A SAR_validpin_0/DFFR_7/a_2090_n400# 5.15e-19
C2920 SAR_validpin_0/OR2_2/a_n80_n540# shift1v8to5_3/A 0.103573f
C2921 SAR_validpin_0/DFFRR_0/a_2600_n430# SAR_validpin_0/DFFRR_1/a_2090_n400# 4e-19
C2922 SAR_validpin_0/OR2_1/a_n80_n540# SAR_validpin_0/OR2_2/a_n80_n540# 8.66e-19
C2923 shift5to1v8_0/Y SAR_validpin_0/DFFRR_1/a_n340_n430# 0.042878f
C2924 SAR_validpin_0/DFFS_0/a_350_n430# SAR_validpin_0/OR2_2/B 8.73e-20
C2925 SAR_validpin_0/DFFS_0/a_1130_520# SAR_validpin_0/DFFS_0/a_600_n400# 0.094185f
C2926 VDD1v8 SAR_validpin_0/OR2_0/a_n80_n540# 0.451286f
C2927 SAR_validpin_0/DFFR_1/a_450_n400# CDAC_0/Vout 0.00827f
C2928 SAR_validpin_0/DFFR_1/a_n50_n400# SAR_validpin_0/DFFR_0/a_2600_n430# 3.57e-19
C2929 SAR_validpin_0/OR2_0/a_100_310# SAR_validpin_0/DFFR_1/a_n50_n400# 7.49e-19
C2930 SAR_validpin_0/DFFS_0/a_2550_n400# SAR_validpin_0/DFFS_0/a_450_n400# 0.007181f
C2931 SAR_validpin_0/DFFR_2/a_1130_520# SAR_validpin_0/DFFR_2/a_n420_n400# 0.088465f
C2932 shift1v8to5_2/5v_pfet_1_2_2/D strongarm_0/5v_pfet_1_1_0/D 5.32e-20
C2933 SAR_validpin_0/DFFR_0/a_450_n400# shift1v8to5_0/A 3.91e-19
C2934 SAR_validpin_0/DFFRR_1/a_2600_n430# SAR_validpin_0/DFFR_4/a_n50_n400# 3.44e-19
C2935 SAR_validpin_0/DFFR_7/a_2600_n430# VDD1v8 0.991656f
C2936 VDD1v8 CDAC_0/b0 1.250234f
C2937 SRLatch5V_0/R CDAC_0/b2 0.006222f
C2938 CLK5 shift1v8to5_5/5v_pfet_1_2_2/D 1.046041f
C2939 SAR_validpin_0/DFFR_6/a_1130_520# SAR_validpin_0/DFFR_6/a_2090_n400# 1.24e-20
C2940 shift1v8to5_1/A SAR_validpin_0/DFFR_7/a_n50_n400# 4.8e-19
C2941 SAR_validpin_0/DFFR_4/a_2600_n430# SAR_validpin_0/DFFR_5/a_2600_n430# 0.010329f
C2942 shift1v8to5_2/5v_pfet_1_2_0/D VDD_5V 0.130833f
C2943 SAR_validpin_0/AND2_1/a_n100_1100# SAR_validpin_0/OR2_0/B 0.066461f
C2944 SAR_validpin_0/DFFR_7/a_2600_n430# SAR_validpin_0/DFFRR_0/a_3210_n400# 9.33e-20
C2945 SAR_validpin_0/DFFR_6/a_n50_n400# SAR_validpin_0/AND2_1/Y 0.228668f
C2946 SAR_validpin_0/OR2_1/A RST_N 0.300213f
C2947 SAR_validpin_0/DFFR_5/a_3210_n400# VDD_5V 0.001782f
C2948 VDD_5V shift1v8to5_5/5v_pfet_1_2_2/D 1.961813f
C2949 shift5to1v8_0/Y SAR_validpin_0/DFFRR_0/a_450_n400# 2.81e-19
C2950 SAR_validpin_0/DFFR_2/a_n420_n400# SAR_validpin_0/DFFR_2/a_1310_n400# 0.001016f
C2951 VDD1v8 SRLatch5V_0/Q 0.243027f
C2952 SAR_validpin_0/DFFR_1/a_n420_n400# SAR_validpin_0/DFFR_0/a_2600_n430# 0.130291f
C2953 SAR_validpin_0/DFFR_7/a_1310_n400# SAR_validpin_0/DFFR_7/a_n50_n400# 0.006175f
C2954 SAR_validpin_0/DFFR_6/a_1130_520# SAR_validpin_0/DFFR_6/a_1310_n400# 0.002821f
C2955 SAR_validpin_0/AND2_0/Y SAR_validpin_0/DFFR_6/a_90_n400# 0.069925f
C2956 shift5to1v8_0/Y SAR_validpin_0/2_1_MUX_1/a_n1230_n310# 0.236773f
C2957 SAR_validpin_0/DFFR_2/a_n50_n400# SAR_validpin_0/DFFR_1/a_2600_n430# 3.57e-19
C2958 SAR_validpin_0/DFFR_4/a_350_n430# SAR_validpin_0/DFFRR_1/a_2090_n400# 1.34e-19
C2959 shift1v8to5_1/A SAR_validpin_0/DFFR_0/a_2090_n400# 0.038126f
C2960 SAR_validpin_0/AND2_0/Y SAR_validpin_0/DFFR_3/a_1310_n400# 0.003645f
C2961 SAR_validpin_0/DFFR_4/a_2600_n430# SAR_validpin_0/DFFR_4/a_350_n430# 2.63e-19
C2962 ADC_OUT1 SAR_validpin_0/DFFR_4/a_3210_n400# 0.007472f
C2963 SARclkgen_0/PHIA SAR_validpin_0/DFFR_1/a_90_n400# 0.099834f
C2964 SAR_validpin_0/OR2_2/B SAR_validpin_0/OR2_2/a_n80_n540# 0.22213f
C2965 SAR_validpin_0/DFFR_2/a_450_n400# RST_N 0.364427f
C2966 SAR_validpin_0/DFFR_3/a_n420_n400# SAR_validpin_0/DFFR_3/a_1130_520# 0.088465f
C2967 ADC_OUT1 SAR_validpin_0/DFFR_3/a_2090_n400# 0.001288f
C2968 VDD1v8 SAR_validpin_0/DFFR_0/a_2600_n430# 0.986368f
C2969 SAR_validpin_0/OR2_0/a_100_310# VDD1v8 0.026043f
C2970 CDAC_0/b0 CDAC_0/SPDT_2/out 0.6915f
C2971 SAR_validpin_0/DFFR_7/D NOT5V_0/Y 1.35e-19
C2972 SAR_validpin_0/DFFR_7/D SAR_validpin_0/DFFR_7/a_n420_n400# 0.077913f
C2973 RST_N SAR_validpin_0/DFFRR_1/a_n560_n400# 0.171815f
C2974 SARclkgen_0/AND2_0/a_90_n200# SARclkgen_0/AND2_0/a_n100_1100# 0.011051f
C2975 SARclkgen_0/PHIB SARclkgen_0/AND2_0/A 0.873954f
C2976 SAR_validpin_0/DFFR_0/a_1130_520# shift1v8to5_3/A 1.17e-19
C2977 shift1v8to5_1/A SAR_validpin_0/DFFS_0/a_450_n400# 0.125621f
C2978 NOT5V_0/Y shift1v8to5_4/5v_pfet_1_2_0/D 1.51e-19
C2979 SAR_validpin_0/DFFR_5/a_90_n400# SAR_validpin_0/DFFR_5/a_350_n430# 0.349264f
C2980 VDD_5V shift1v8to5_3/5v_pfet_1_2_2/D 2.25068f
C2981 CDAC_0/Vcm CDAC_0/b2 0.868592f
C2982 SAR_validpin_0/DFFR_6/a_90_n400# VALID 3.37e-19
C2983 SAR_validpin_0/DFFR_2/a_n50_n400# SAR_validpin_0/DFFR_1/a_2090_n400# 4.83e-19
C2984 SAR_validpin_0/DFFR_0/a_450_n400# SARclkgen_0/PHIB 0.879775f
C2985 SAR_validpin_0/DFFR_6/a_90_n400# VDD_5V 0.004852f
C2986 SARclkgen_0/AND2_0/B SARclkgen_0/AND2_0/a_n100_1100# 0.158811f
C2987 CLK5 SAR_validpin_0/DFFR_1/a_90_n400# 1.08e-20
C2988 SAR_validpin_0/DFFS_0/a_450_n400# SAR_validpin_0/DFFS_0/a_1460_n400# 0.011372f
C2989 CDAC_0/SPDT_0/out shift1v8to5_1/5v_pfet_1_2_2/D 0.012079f
C2990 shift1v8to5_3/5v_pfet_1_2_2/D SRLatch5V_0/NAND5v_0/5v_nfet_1_2_1/D 2.42e-19
C2991 SAR_validpin_0/DFFR_7/a_3210_n400# SAR_validpin_0/DFFR_7/a_n50_n400# 2.5e-19
C2992 SAR_validpin_0/DFFR_3/a_n420_n400# SAR_validpin_0/AND2_1/Y 0.683415f
C2993 VDD_5V SAR_validpin_0/DFFR_1/a_90_n400# 0.003289f
C2994 CDAC_0/SPDT_0/out NOT5V_0/Y 2.76563f
C2995 shift5to1v8_0/5v_pfet_1_2_1/G SRLatch5V_0/NQ 0.634217f
C2996 SAR_validpin_0/DFFR_6/a_350_n430# RST_N 0.222513f
C2997 SAR_validpin_0/DFFR_3/D SAR_validpin_0/DFFR_4/a_n50_n400# 0.001842f
C2998 SAR_validpin_0/DFFS_0/a_350_n430# SAR_validpin_0/DFFS_0/a_2550_720# 2.48e-19
C2999 Vin CDAC_0/SPDT_3/out 4.501f
C3000 SAR_validpin_0/DFFR_0/a_1130_520# SAR_validpin_0/OR2_2/B 0.017086f
C3001 SAR_validpin_0/DFFS_0/a_n50_n400# shift1v8to5_1/A 0.124835f
C3002 SAR_validpin_0/DFFS_0/a_1130_520# SARclkgen_0/PHIB 0.135169f
C3003 SARclkgen_0/PHIA SAR_validpin_0/DFFR_2/a_n420_n400# 0.107123f
C3004 CDAC_0/SPDT_4/out SAR_validpin_0/DFFR_0/a_2550_n400# 1.43e-19
C3005 SAR_validpin_0/DFFRR_0/a_n420_720# SAR_validpin_0/DFFR_7/a_n50_n400# 0.003384f
C3006 SAR_validpin_0/DFFR_7/a_2600_n430# SAR_validpin_0/AND2_1/Y 0.008526f
C3007 SAR_validpin_0/DFFR_8/a_1130_520# SARclkgen_0/PHIA 3.17e-19
C3008 SARclkgen_0/PHIA SAR_validpin_0/DFFR_0/a_3210_n400# 0.008573f
C3009 SARclkgen_0/AND2_1/B CLK_comp 0.008713f
C3010 shift5to1v8_0/Y SAR_validpin_0/DFFRR_1/a_450_n400# 0.11996f
C3011 SAR_validpin_0/DFFS_0/a_n50_n400# SAR_validpin_0/DFFS_0/a_1460_n400# 0.01695f
C3012 SAR_validpin_0/DFFR_4/a_n50_n400# VDD1v8 0.503167f
C3013 shift5to1v8_0/Y shift1v8to5_5/5v_pfet_1_2_2/D 1.84e-19
C3014 shift1v8to5_1/A SAR_validpin_0/DFFR_1/a_450_n400# 0.05647f
C3015 SARclkgen_0/PHIA SAR_validpin_0/DFFS_0/a_600_n400# 0.23319f
C3016 SAR_validpin_0/AND2_0/Y SAR_validpin_0/DFFR_5/a_350_n430# 0.093324f
C3017 SAR_validpin_0/DFFR_1/a_350_n430# SAR_validpin_0/DFFR_1/a_90_n400# 0.349264f
C3018 SAR_validpin_0/DFFR_7/a_1130_520# SAR_validpin_0/DFFRR_0/a_1460_n400# 2.11e-19
C3019 RST_N SAR_validpin_0/DFFR_7/a_2090_n400# 0.46204f
C3020 SARclkgen_0/PHIB SAR_validpin_0/DFFR_2/a_1130_520# 0.115688f
C3021 SAR_validpin_0/DFFR_3/a_350_n430# SAR_validpin_0/DFFR_3/a_2600_n430# 2.63e-19
C3022 CDAC_0/SPDT_2/out VSS 4.593938f
C3023 CDAC_0/b1 VSS 6.224801f
C3024 CDAC_0/SPDT_1/out VSS 3.343418f
C3025 CDAC_0/b2 VSS 5.192248f
C3026 NOT5V_0/Y VSS 16.502466f
C3027 Vin VSS 9.536882f
C3028 VDD_5V VSS 0.246407p
C3029 CDAC_0/SPDT_0/out VSS 4.150206f
C3030 CLK5 VSS 22.324503f
C3031 CDAC_0/b3 VSS 4.569446f
C3032 CDAC_0/Vcm VSS 19.641277f
C3033 CDAC_0/Vout VSS 26.95779f
C3034 CDAC_0/SPDT_3/out VSS 3.892172f
C3035 CDAC_0/b0 VSS 7.674303f
C3036 CDAC_0/SPDT_4/out VSS 4.621704f
C3037 SARclkgen_0/AND2_1/a_90_n200# VSS 0.012271f
C3038 SARclkgen_0/AND2_1/a_n100_1100# VSS 1.627091f
C3039 SARclkgen_0/AND2_0/a_90_n200# VSS 0.012453f
C3040 SARclkgen_0/AND2_0/a_n100_1100# VSS 1.630375f
C3041 SARclkgen_0/AND2_0/A VSS 2.454689f
C3042 SARclkgen_0/AND2_0/B VSS 1.624703f
C3043 SARclkgen_0/AND2_1/B VSS 1.769139f
C3044 strongarm_0/5v_pfet_1_1_0/D VSS 0.618621f
C3045 strongarm_0/5v_pfet_1_1_3/D VSS 0.58325f
C3046 strongarm_0/5v_nfet_1_1_3/S VSS 0.917839f
C3047 strongarm_0/clk VSS 7.252178f
C3048 SRLatch5V_0/R VSS 3.650164f
C3049 SRLatch5V_0/S VSS 2.569405f
C3050 shift1v8to5_5/5v_pfet_1_2_0/D VSS 2.221438f
C3051 CLK VSS 12.499947f
C3052 shift1v8to5_5/5v_pfet_1_2_2/D VSS 2.512972f
C3053 shift5to1v8_0/5v_pfet_1_2_1/G VSS 2.409478f
C3054 shift1v8to5_4/5v_pfet_1_2_0/D VSS 2.221354f
C3055 CLK_comp VSS 6.645746f
C3056 shift1v8to5_4/5v_pfet_1_2_2/D VSS 2.514506f
C3057 SARclkgen_0/PHIA VSS 29.995213f
C3058 SAR_validpin_0/OR2_1/B VSS 3.531922f
C3059 SAR_validpin_0/OR2_2/B VSS 5.389997f
C3060 shift1v8to5_1/A VSS 12.172927f
C3061 SARclkgen_0/PHIB VSS 18.252602f
C3062 RST_N VSS 20.035852f
C3063 SAR_validpin_0/DFFS_0/a_3210_n400# VSS 0.016338f
C3064 SAR_validpin_0/DFFS_0/a_2550_n400# VSS 0.005727f
C3065 SAR_validpin_0/DFFS_0/a_1460_n400# VSS 0.007529f
C3066 SAR_validpin_0/DFFS_0/a_1310_n400# VSS 0.016286f
C3067 SAR_validpin_0/DFFS_0/a_2090_n400# VSS 1.311062f
C3068 SAR_validpin_0/DFFS_0/a_600_n400# VSS 0.978907f
C3069 SAR_validpin_0/DFFS_0/a_90_n400# VSS 0.527448f
C3070 SAR_validpin_0/DFFS_0/a_n420_n400# VSS 1.169922f
C3071 SAR_validpin_0/DFFS_0/a_350_n430# VSS 0.970478f
C3072 SAR_validpin_0/DFFS_0/a_1130_520# VSS 0.043595f
C3073 SAR_validpin_0/DFFS_0/a_n50_n400# VSS 0.701328f
C3074 SAR_validpin_0/DFFS_0/a_450_n400# VSS 2.571327f
C3075 SAR_validpin_0/DFFR_3/D VSS 1.439229f
C3076 shift5to1v8_0/Y VSS 5.545342f
C3077 SAR_validpin_0/AND2_2/a_90_n200# VSS 0.016338f
C3078 SAR_validpin_0/AND2_2/a_n100_1100# VSS 1.654953f
C3079 SAR_validpin_0/AND2_1/Y VSS 6.336329f
C3080 SAR_validpin_0/AND2_1/a_90_n200# VSS 0.016338f
C3081 SAR_validpin_0/AND2_1/a_n100_1100# VSS 1.651179f
C3082 VALID VSS 4.308067f
C3083 SAR_validpin_0/DFFR_8/a_3210_n400# VSS 0.017745f
C3084 SAR_validpin_0/DFFR_8/a_2550_n400# VSS 0.00948f
C3085 SAR_validpin_0/DFFR_8/a_1460_n400# VSS 0.007529f
C3086 SAR_validpin_0/DFFR_8/a_1310_n400# VSS 0.016286f
C3087 SAR_validpin_0/DFFR_8/a_2550_720# VSS 7.63e-19
C3088 SAR_validpin_0/DFFR_8/a_2600_n430# VSS 1.565747f
C3089 SAR_validpin_0/DFFR_8/a_2090_n400# VSS 1.244033f
C3090 SAR_validpin_0/DFFR_8/a_90_n400# VSS 0.525727f
C3091 SAR_validpin_0/DFFR_8/a_n420_n400# VSS 0.824208f
C3092 SAR_validpin_0/DFFR_8/a_350_n430# VSS 0.929088f
C3093 SAR_validpin_0/DFFR_8/a_1130_520# VSS 0.043595f
C3094 SAR_validpin_0/DFFR_8/a_n50_n400# VSS 1.08779f
C3095 SAR_validpin_0/DFFR_8/a_450_n400# VSS 1.10434f
C3096 SAR_validpin_0/AND2_0/Y VSS 9.863033f
C3097 SAR_validpin_0/AND2_0/a_90_n200# VSS 0.015678f
C3098 SAR_validpin_0/AND2_0/a_n100_1100# VSS 1.647514f
C3099 SAR_validpin_0/DFFR_7/a_3210_n400# VSS 0.016338f
C3100 SAR_validpin_0/DFFR_7/a_2550_n400# VSS 0.009018f
C3101 SAR_validpin_0/DFFR_7/a_1460_n400# VSS 0.007529f
C3102 SAR_validpin_0/DFFR_7/a_1310_n400# VSS 0.016286f
C3103 SAR_validpin_0/DFFR_7/a_2600_n430# VSS 1.533476f
C3104 SAR_validpin_0/DFFR_7/a_2090_n400# VSS 1.235817f
C3105 SAR_validpin_0/DFFR_7/a_90_n400# VSS 0.528741f
C3106 SAR_validpin_0/DFFR_7/a_n420_n400# VSS 0.823521f
C3107 SAR_validpin_0/DFFR_7/a_350_n430# VSS 0.934324f
C3108 SAR_validpin_0/DFFR_7/a_1130_520# VSS 0.043785f
C3109 SAR_validpin_0/DFFR_7/a_n50_n400# VSS 1.088845f
C3110 SAR_validpin_0/DFFR_7/a_450_n400# VSS 1.109934f
C3111 ADC_OUT3 VSS 2.821395f
C3112 SAR_validpin_0/DFFR_6/a_3210_n400# VSS 0.016188f
C3113 SAR_validpin_0/DFFR_6/a_2550_n400# VSS 0.009018f
C3114 SAR_validpin_0/DFFR_6/a_1460_n400# VSS 0.007529f
C3115 SAR_validpin_0/DFFR_6/a_1310_n400# VSS 0.016286f
C3116 SAR_validpin_0/DFFR_6/a_2600_n430# VSS 1.533244f
C3117 SAR_validpin_0/DFFR_6/a_2090_n400# VSS 1.235271f
C3118 SAR_validpin_0/DFFR_6/a_90_n400# VSS 0.528741f
C3119 SAR_validpin_0/DFFR_6/a_n420_n400# VSS 0.885233f
C3120 SAR_validpin_0/DFFR_6/a_350_n430# VSS 0.951456f
C3121 SAR_validpin_0/DFFR_6/a_1130_520# VSS 0.043785f
C3122 SAR_validpin_0/DFFR_6/a_n50_n400# VSS 1.106272f
C3123 SAR_validpin_0/DFFR_6/a_450_n400# VSS 1.116258f
C3124 ADC_OUT2 VSS 2.797936f
C3125 SAR_validpin_0/DFFR_5/a_3210_n400# VSS 0.01701f
C3126 SAR_validpin_0/DFFR_5/a_2550_n400# VSS 0.009813f
C3127 SAR_validpin_0/DFFR_5/a_1460_n400# VSS 0.009898f
C3128 SAR_validpin_0/DFFR_5/a_1310_n400# VSS 0.018365f
C3129 SAR_validpin_0/DFFR_5/a_2550_720# VSS 0.001312f
C3130 SAR_validpin_0/DFFR_5/a_2600_n430# VSS 1.562222f
C3131 SAR_validpin_0/DFFR_5/a_2090_n400# VSS 1.271175f
C3132 SAR_validpin_0/DFFR_5/a_90_n400# VSS 0.53923f
C3133 SAR_validpin_0/DFFR_5/a_n420_n400# VSS 0.902947f
C3134 SAR_validpin_0/DFFR_5/a_350_n430# VSS 1.015868f
C3135 SAR_validpin_0/DFFR_5/a_1130_520# VSS 0.059719f
C3136 SAR_validpin_0/DFFR_5/a_n50_n400# VSS 1.165851f
C3137 SAR_validpin_0/DFFR_5/a_450_n400# VSS 1.182f
C3138 ADC_OUT1 VSS 2.054453f
C3139 SAR_validpin_0/DFFR_4/a_3210_n400# VSS 0.01701f
C3140 SAR_validpin_0/DFFR_4/a_2550_n400# VSS 0.009813f
C3141 SAR_validpin_0/DFFR_4/a_1460_n400# VSS 0.009898f
C3142 SAR_validpin_0/DFFR_4/a_1310_n400# VSS 0.018365f
C3143 SAR_validpin_0/DFFR_4/a_2550_720# VSS 0.001312f
C3144 SAR_validpin_0/DFFR_4/a_2600_n430# VSS 1.562221f
C3145 SAR_validpin_0/DFFR_4/a_2090_n400# VSS 1.271174f
C3146 SAR_validpin_0/DFFR_4/a_90_n400# VSS 0.53923f
C3147 SAR_validpin_0/DFFR_4/a_n420_n400# VSS 0.902946f
C3148 SAR_validpin_0/DFFR_4/a_350_n430# VSS 1.011044f
C3149 SAR_validpin_0/DFFR_4/a_1130_520# VSS 0.059719f
C3150 SAR_validpin_0/DFFR_4/a_n50_n400# VSS 1.166381f
C3151 SAR_validpin_0/DFFR_4/a_450_n400# VSS 1.189158f
C3152 SAR_validpin_0/DFFR_2/a_3210_n400# VSS 0.01701f
C3153 SAR_validpin_0/DFFR_2/a_2550_n400# VSS 0.009813f
C3154 SAR_validpin_0/DFFR_2/a_1460_n400# VSS 0.009898f
C3155 SAR_validpin_0/DFFR_2/a_1310_n400# VSS 0.018365f
C3156 SAR_validpin_0/DFFR_2/a_2550_720# VSS 0.001312f
C3157 SAR_validpin_0/DFFR_2/a_2600_n430# VSS 1.553546f
C3158 SAR_validpin_0/DFFR_2/a_2090_n400# VSS 1.263759f
C3159 SAR_validpin_0/DFFR_2/a_90_n400# VSS 0.535276f
C3160 SAR_validpin_0/DFFR_2/a_n420_n400# VSS 0.894369f
C3161 SAR_validpin_0/DFFR_2/a_350_n430# VSS 1.006237f
C3162 SAR_validpin_0/DFFR_2/a_1130_520# VSS 0.057061f
C3163 SAR_validpin_0/DFFR_2/a_n50_n400# VSS 1.158168f
C3164 SAR_validpin_0/DFFR_2/a_450_n400# VSS 1.174469f
C3165 ADC_OUT0 VSS 2.162755f
C3166 SAR_validpin_0/DFFR_3/a_3210_n400# VSS 0.01701f
C3167 SAR_validpin_0/DFFR_3/a_2550_n400# VSS 0.009813f
C3168 SAR_validpin_0/DFFR_3/a_1460_n400# VSS 0.009898f
C3169 SAR_validpin_0/DFFR_3/a_1310_n400# VSS 0.018365f
C3170 SAR_validpin_0/DFFR_3/a_2550_720# VSS 0.001312f
C3171 SAR_validpin_0/DFFR_3/a_2600_n430# VSS 1.562222f
C3172 SAR_validpin_0/DFFR_3/a_2090_n400# VSS 1.271175f
C3173 SAR_validpin_0/DFFR_3/a_90_n400# VSS 0.53923f
C3174 SAR_validpin_0/DFFR_3/a_n420_n400# VSS 0.833619f
C3175 SAR_validpin_0/DFFR_3/a_350_n430# VSS 1.011718f
C3176 SAR_validpin_0/DFFR_3/a_1130_520# VSS 0.059719f
C3177 SAR_validpin_0/DFFR_3/a_n50_n400# VSS 1.168038f
C3178 SAR_validpin_0/DFFR_3/a_450_n400# VSS 1.190625f
C3179 SAR_validpin_0/DFFRR_1/a_3210_n400# VSS 0.016623f
C3180 SAR_validpin_0/DFFRR_1/a_2550_n400# VSS 0.009018f
C3181 SAR_validpin_0/DFFRR_1/a_1460_n400# VSS 0.007529f
C3182 SAR_validpin_0/DFFRR_1/a_1310_n400# VSS 0.016286f
C3183 SAR_validpin_0/DFFRR_1/a_2600_n430# VSS 1.537851f
C3184 SAR_validpin_0/DFFRR_1/a_2090_n400# VSS 1.240408f
C3185 SAR_validpin_0/DFFRR_1/a_n240_n400# VSS 0.011007f
C3186 SAR_validpin_0/DFFRR_1/a_n420_720# VSS 0.567187f
C3187 SAR_validpin_0/DFFRR_1/a_n930_n400# VSS 0.827873f
C3188 SAR_validpin_0/DFFRR_1/a_350_n430# VSS 0.938603f
C3189 SAR_validpin_0/DFFRR_1/a_n340_n430# VSS 0.697754f
C3190 SAR_validpin_0/DFFRR_1/a_1130_520# VSS 0.045695f
C3191 SAR_validpin_0/DFFRR_1/a_n560_n400# VSS 1.297584f
C3192 SAR_validpin_0/DFFRR_1/a_450_n400# VSS 1.106711f
C3193 SAR_validpin_0/OR2_0/B VSS 4.465328f
C3194 SAR_validpin_0/DFFR_1/a_3210_n400# VSS 0.016338f
C3195 SAR_validpin_0/DFFR_1/a_2550_n400# VSS 0.009018f
C3196 SAR_validpin_0/DFFR_1/a_1460_n400# VSS 0.007529f
C3197 SAR_validpin_0/DFFR_1/a_1310_n400# VSS 0.016286f
C3198 SAR_validpin_0/DFFR_1/a_2600_n430# VSS 1.528121f
C3199 SAR_validpin_0/DFFR_1/a_2090_n400# VSS 1.23059f
C3200 SAR_validpin_0/DFFR_1/a_90_n400# VSS 0.525665f
C3201 SAR_validpin_0/DFFR_1/a_n420_n400# VSS 0.881772f
C3202 SAR_validpin_0/DFFR_1/a_350_n430# VSS 0.92892f
C3203 SAR_validpin_0/DFFR_1/a_1130_520# VSS 0.043595f
C3204 SAR_validpin_0/DFFR_1/a_n50_n400# VSS 1.084846f
C3205 SAR_validpin_0/DFFR_1/a_450_n400# VSS 1.10432f
C3206 SAR_validpin_0/DFFRR_0/a_3210_n400# VSS 0.016338f
C3207 SAR_validpin_0/DFFRR_0/a_2550_n400# VSS 0.009018f
C3208 SAR_validpin_0/DFFRR_0/a_1460_n400# VSS 0.007529f
C3209 SAR_validpin_0/DFFRR_0/a_1310_n400# VSS 0.016286f
C3210 SAR_validpin_0/DFFRR_0/a_2600_n430# VSS 1.533382f
C3211 SAR_validpin_0/DFFRR_0/a_2090_n400# VSS 1.235554f
C3212 SAR_validpin_0/DFFRR_0/a_n240_n400# VSS 0.011007f
C3213 SAR_validpin_0/DFFRR_0/a_n420_720# VSS 0.562556f
C3214 SAR_validpin_0/DFFRR_0/a_n930_n400# VSS 0.827137f
C3215 SAR_validpin_0/DFFRR_0/a_350_n430# VSS 0.933478f
C3216 SAR_validpin_0/DFFRR_0/a_n340_n430# VSS 0.697673f
C3217 SAR_validpin_0/DFFRR_0/a_1130_520# VSS 0.043785f
C3218 SAR_validpin_0/DFFRR_0/a_n560_n400# VSS 1.297295f
C3219 SAR_validpin_0/DFFRR_0/a_450_n400# VSS 1.106194f
C3220 SAR_validpin_0/DFFR_0/a_3210_n400# VSS 0.016338f
C3221 SAR_validpin_0/DFFR_0/a_2550_n400# VSS 0.009018f
C3222 SAR_validpin_0/DFFR_0/a_1460_n400# VSS 0.007529f
C3223 SAR_validpin_0/DFFR_0/a_1310_n400# VSS 0.016286f
C3224 SAR_validpin_0/DFFR_0/a_2600_n430# VSS 1.528121f
C3225 SAR_validpin_0/DFFR_0/a_2090_n400# VSS 1.23059f
C3226 SAR_validpin_0/DFFR_0/a_90_n400# VSS 0.525665f
C3227 SAR_validpin_0/DFFR_0/a_n420_n400# VSS 0.881723f
C3228 SAR_validpin_0/DFFR_0/a_350_n430# VSS 0.92892f
C3229 SAR_validpin_0/DFFR_0/a_1130_520# VSS 0.043595f
C3230 SAR_validpin_0/DFFR_0/a_n50_n400# VSS 1.084846f
C3231 SAR_validpin_0/DFFR_0/a_450_n400# VSS 1.10432f
C3232 SAR_validpin_0/DFFR_7/D VSS 1.074572f
C3233 SAR_validpin_0/2_1_MUX_2/a_n1230_n310# VSS 0.753995f
C3234 SAR_validpin_0/DFFRR_0/D VSS 0.871611f
C3235 SAR_validpin_0/2_1_MUX_1/a_n1230_n310# VSS 0.789579f
C3236 SAR_validpin_0/OR2_2/A VSS 3.918078f
C3237 SAR_validpin_0/OR2_2/a_n80_n540# VSS 1.26494f
C3238 SAR_validpin_0/DFFRR_1/D VSS 0.872521f
C3239 SAR_validpin_0/2_1_MUX_0/a_n1230_n310# VSS 0.782161f
C3240 SAR_validpin_0/OR2_1/A VSS 3.326675f
C3241 SAR_validpin_0/OR2_1/a_n80_n540# VSS 1.269353f
C3242 SAR_validpin_0/OR2_0/A VSS 3.124052f
C3243 SAR_validpin_0/OR2_0/a_n80_n540# VSS 1.277975f
C3244 SAR_validpin_0/OR2_0/a_100_310# VSS 6.47e-19
C3245 shift1v8to5_3/5v_pfet_1_2_0/D VSS 2.227553f
C3246 shift1v8to5_3/A VSS 6.654605f
C3247 shift1v8to5_3/5v_pfet_1_2_2/D VSS 2.546946f
C3248 shift1v8to5_2/5v_pfet_1_2_0/D VSS 2.224493f
C3249 shift1v8to5_2/A VSS 10.718413f
C3250 shift1v8to5_2/5v_pfet_1_2_2/D VSS 2.562864f
C3251 shift1v8to5_1/5v_pfet_1_2_0/D VSS 2.222254f
C3252 VDD1v8 VSS 0.237407p
C3253 shift1v8to5_1/5v_pfet_1_2_2/D VSS 2.59914f
C3254 SRLatch5V_0/Q VSS 2.250042f
C3255 SRLatch5V_0/NAND5v_1/5v_nfet_1_2_1/D VSS 0.814101f
C3256 SRLatch5V_0/NQ VSS 4.135231f
C3257 SRLatch5V_0/NAND5v_0/5v_nfet_1_2_1/D VSS 0.83361f
C3258 shift1v8to5_0/5v_pfet_1_2_0/D VSS 2.221664f
C3259 shift1v8to5_0/A VSS 8.788859f
C3260 shift1v8to5_0/5v_pfet_1_2_2/D VSS 2.55826f
